* extracted by klt extract --deck gf180mcu

* cell first_stage
* pin ibias
* pin n1
* pin n2
* pin tail
* pin vdd
* pin vinn
* pin vinp
* pin vss
.SUBCKT first_stage vdd vss vinp vinn tail n1 n2 ibias
* device instance $1 r0 *1 9.06,0.9 nfet
X$1 n1 vinn tail vss nfet_03v3 L=1U W=1.8U AS=0.9P AD=0.9P PS=4.6U PD=4.6U
* device instance $2 r0 *1 11.96,0.9 nfet
X$2 n2 vinp tail vss nfet_03v3 L=1U W=1.8U AS=0.9P AD=0.9P PS=4.6U PD=4.6U
* device instance $3 r0 *1 17.77,2.32 nfet
X$3 tail ibias vss vss nfet_03v3 L=2U W=3U AS=1.5P AD=0.87P PS=7U PD=3.58U
* device instance $4 r0 *1 20.35,2.32 nfet
X$4 vss ibias tail vss nfet_03v3 L=2U W=3U AS=0.87P AD=1.5P PS=3.58U PD=7U
* device instance $5 r0 *1 9.06,4.52 nfet
X$5 n2 vinp tail vss nfet_03v3 L=1U W=1.8U AS=0.9P AD=0.9P PS=4.6U PD=4.6U
* device instance $6 r0 *1 11.96,4.52 nfet
X$6 n1 vinn tail vss nfet_03v3 L=1U W=1.8U AS=0.9P AD=0.9P PS=4.6U PD=4.6U
* device instance $7 r0 *1 1,1.5 pfet
X$7 n1 n1 vdd vdd pfet_03v3 L=1U W=3U AS=1.5P AD=1.5P PS=7U PD=7U
* device instance $8 r0 *1 3.9,1.5 pfet
X$8 n2 n1 vdd vdd pfet_03v3 L=1U W=3U AS=1.5P AD=1.5P PS=7U PD=7U
* device instance $9 r0 *1 1,6.32 pfet
X$9 n2 n1 vdd vdd pfet_03v3 L=1U W=3U AS=1.5P AD=1.5P PS=7U PD=7U
* device instance $10 r0 *1 3.9,6.32 pfet
X$10 n1 n1 vdd vdd pfet_03v3 L=1U W=3U AS=1.5P AD=1.5P PS=7U PD=7U
.ENDS first_stage
