* Extracted by KLayout with GF180MCU LVS runset on : 10/10/2026 00:18

.SUBCKT pilot_pfet_m3_m4 B D S G
M$1 D G S B pfet_03v3 L=1U W=6U AS=2.37P AD=2.37P PS=10.58U PD=10.58U
.ENDS pilot_pfet_m3_m4
