* extracted by klt extract --deck gf180mcu

* cell pilot_nfet_mb1_m5
* pin B
* pin D
* pin G
* pin S
.SUBCKT pilot_nfet_mb1_m5 B D G S
* device instance $1 r0 *1 1.5,2.32 nfet
X$1 D G S B nfet_03v3 L=2U W=3U AS=1.5P AD=0.87P PS=7U PD=3.58U
* device instance $2 r0 *1 4.08,2.32 nfet
X$2 S G D B nfet_03v3 L=2U W=3U AS=0.87P AD=1.5P PS=3.58U PD=7U
.ENDS pilot_nfet_mb1_m5
