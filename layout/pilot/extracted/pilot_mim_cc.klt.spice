* extracted by klt extract --deck gf180mcu

* cell pilot_mim_cc
* pin BOT
* pin TOP
.SUBCKT pilot_mim_cc BOT TOP
* device instance $1 r0 *1 9.46,9.46 cap_mim_2f0_m4m5_noshield
X$1 BOT TOP cap_mim_2f0_m4m5_noshield c_length=16.8U c_width=16.8U
.ENDS pilot_mim_cc
