* schematic-derived reference for pilot_nfet_mb1_m5 (dimensions from XMB1+XM5; ad/as/pd/ps omitted)
.subckt pilot_nfet_mb1_m5 D G S B
XM1 D G S B nfet_03v3 L=2u W=6u nf=2 m=1
.ends
