* schematic-derived reference, foundry-runset form, for pilot_pfet_m3_m4
.subckt pilot_pfet_m3_m4 D G S B
M1 D G S B pfet_03v3 L=1u W=6u
.ends
