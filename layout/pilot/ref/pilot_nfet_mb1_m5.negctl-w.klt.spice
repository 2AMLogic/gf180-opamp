* NEGATIVE CONTROL for pilot_nfet_mb1_m5 -- w is deliberately 12u (schematic value 6u).
* klt lvs must report a mismatch with a device.property error against the
* unchanged gds/pilot_nfet_mb1_m5.gds; a match here would mean the device-parameter
* compare is insensitive to the dimensions this pilot claims it checks,
* and tools/pilot.py exits non-zero.
.subckt pilot_nfet_mb1_m5 D G S B
XM1 D G S B nfet_03v3 L=2u W=12u nf=2 m=1
.ends
