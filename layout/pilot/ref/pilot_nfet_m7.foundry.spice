* schematic-derived reference, foundry-runset form, for pilot_nfet_m7
.subckt pilot_nfet_m7 D G S B
M1 D G S B nfet_03v3 L=2u W=36u
.ends
