* gf180-opamp Stage A (issue #295, DR-0008 section 4)
.lib '/home/ubuntu/.ciel/gf180mcuD/libs.tech/ngspice/sm141064.ngspice' typical
.lib '/home/ubuntu/.ciel/gf180mcuD/libs.tech/ngspice/sm141064.ngspice' res_typical
.lib '/home/ubuntu/.ciel/gf180mcuD/libs.tech/ngspice/sm141064.ngspice' mimcap_typical
.temp 27

* tb_region.spice -- Stage A step 1: CLOSURE-INDEPENDENT region check
* (spec/decision-records/0008, section 4 "DC operating-point method" item 1).
*
* No loop to close: VC is forced by an ideal source at the bias level, FBN
* (the amplifier's inverting input) and VREF (non-inverting) both at 0.6 V, the
* common mode the consumer applies. `.op` then reports the regions and
* currents of XM1/XM2/XM5 (input pair and tail do not depend on VC). The
* consumer network is not instantiated: FBN and VC are forced, so it would be
* inert at DC. The DUT is the committed export via `opamp_two_stage.dut.spice`.

.include '/tmp/buck-stage-a-4shji_tq/design.ngspice'
.include '/tmp/buck-stage-a-4shji_tq/opamp_two_stage.dut.spice'

.param vcb=1.25 vref=1.5

Vdd vdd 0 dc 3.3
Ibias vdd ibias dc 10u
Vref vinp 0 dc {vref}
Vfbn fbn 0 dc {vref}
Vvc vc 0 dc {vcb}
Xdut vdd 0 vinp fbn vc ibias opamp_two_stage

.control
op
print v(xdut.tail) v(xdut.n1) v(xdut.n2) v(xdut.nz) v(vc) v(fbn) v(vinp)
print @m.xdut.xm1.m0[id]
print @m.xdut.xm1.m0[vgs]
print @m.xdut.xm1.m0[vds]
print @m.xdut.xm1.m0[vth]
print @m.xdut.xm1.m0[vdsat]
print @m.xdut.xm1.m0[gm]
print @m.xdut.xm1.m0[gds]
print @m.xdut.xm2.m0[id]
print @m.xdut.xm2.m0[vgs]
print @m.xdut.xm2.m0[vds]
print @m.xdut.xm2.m0[vth]
print @m.xdut.xm2.m0[vdsat]
print @m.xdut.xm2.m0[gm]
print @m.xdut.xm2.m0[gds]
print @m.xdut.xm3.m0[id]
print @m.xdut.xm3.m0[vgs]
print @m.xdut.xm3.m0[vds]
print @m.xdut.xm3.m0[vth]
print @m.xdut.xm3.m0[vdsat]
print @m.xdut.xm3.m0[gm]
print @m.xdut.xm3.m0[gds]
print @m.xdut.xm4.m0[id]
print @m.xdut.xm4.m0[vgs]
print @m.xdut.xm4.m0[vds]
print @m.xdut.xm4.m0[vth]
print @m.xdut.xm4.m0[vdsat]
print @m.xdut.xm4.m0[gm]
print @m.xdut.xm4.m0[gds]
print @m.xdut.xm5.m0[id]
print @m.xdut.xm5.m0[vgs]
print @m.xdut.xm5.m0[vds]
print @m.xdut.xm5.m0[vth]
print @m.xdut.xm5.m0[vdsat]
print @m.xdut.xm5.m0[gm]
print @m.xdut.xm5.m0[gds]
print @m.xdut.xm6.m0[id]
print @m.xdut.xm6.m0[vgs]
print @m.xdut.xm6.m0[vds]
print @m.xdut.xm6.m0[vth]
print @m.xdut.xm6.m0[vdsat]
print @m.xdut.xm6.m0[gm]
print @m.xdut.xm6.m0[gds]
print @m.xdut.xm7.m0[id]
print @m.xdut.xm7.m0[vgs]
print @m.xdut.xm7.m0[vds]
print @m.xdut.xm7.m0[vth]
print @m.xdut.xm7.m0[vdsat]
print @m.xdut.xm7.m0[gm]
print @m.xdut.xm7.m0[gds]
print @m.xdut.xmb1.m0[id]
print @m.xdut.xmb1.m0[vgs]
print @m.xdut.xmb1.m0[vds]
print @m.xdut.xmb1.m0[vth]
print @m.xdut.xmb1.m0[vdsat]
print @m.xdut.xmb1.m0[gm]
print @m.xdut.xmb1.m0[gds]
.endc
.end
