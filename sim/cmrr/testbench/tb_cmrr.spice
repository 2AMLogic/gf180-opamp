* tb_cmrr.spice -- differential- and common-mode AC testbench for the committed
* sized schematic (issue #39; spec row: CMRR; DR-3 residual (e3)).
*
* DEVICE UNDER TEST: the committed xschem export
* design/netlist/opamp_two_stage.spice, instantiated as `opamp_two_stage`
* (ports: vdd vss vinp vinn vout ibias). NO TRANSISTOR IS DECLARED IN THIS
* FILE. The driver (run_cmrr.py) materialises `opamp_two_stage.dut.spice` from
* the committed export by the wrapper normalisation the gain bench uses
* (uncomment xschem's `**.subckt`/`**.ends`, drop `.end`) and rewrites the two
* `.include` targets below to absolute paths of the per-run work directory.
* test_cmrr.py guards both includes and the absence of transistors.
*
* This file is a CIRCUIT BODY in `klt sim`'s sense: no `.lib`, `.temp`,
* `.control` or `.end`. `klt sim` adds the corner's `.lib` cards, `.temp`, the
* supply `alter`s and the `.ac` analysis.
*
* ---- Bias and load (design/README.md; spec/target-spec.md Sec.1) ----
*   - Ibias: 10 uA driven INTO the `ibias` node from vdd (ideal source: zero
*     small-signal current).
*   - CL = 2 pF [DR-1] on vout, to ground.
*   - DC input common mode = VDD/2: `Vcm` and `Vdd` are swept together by
*     `klt sim` (corners.supply_v keys vdd and vcm move by index).
*
* ---- DC servo that admits equal AC drive on BOTH inputs ----
* The gain bench's `Cfb vinn 0` AC-grounds the inverting input, so it cannot
* apply a common-mode signal; and its `Lfb vout vinn` would, under CM drive,
* inject (v(vinn) / j*w*Lfb) into the high-impedance output node. Here the DC
* loop is closed by an ideal servo that does not touch vout:
*
*   Esb  buffers vout (VCVS input: no load on vout);
*   Rsv/Csv low-pass it with tau = rsv*csv (1e18 s nominal: the servo is DC
*        only; at 0.1 Hz its AC transfer is 1/(2*pi*0.1*tau) ~ 1.6e-18);
*   Esv  puts that DC level in series with the AC source Vnac:
*        v(vinn) = v(vsv) + v(vnac).
*
* At DC this is the unity-gain-buffer operating point (vinn = vout = VCM, the
* point design/check_dc_op.py verifies). At AC v(vinn) = acn and v(vinp) = acp.
* The driver measures the ACTUAL phasors on both DUT input pins and solves the
* two excitations (differential: acp = +0.5, acn = -0.5; common mode:
* acp = acn = 1) jointly for Ad and Acm, so a residual differential leak in the
* CM run cannot masquerade as common-mode gain; it also rejects a run whose
* phasors are not the intended excitation (inadequate servo, unequal drive).
*
* The `.param` line below is the ONLY line the driver rewrites (per
* excitation mode, and for the servo-isolation study).

.include 'design.ngspice'
.include 'opamp_two_stage.dut.spice'

.param acp=0.5 acn=-0.5 rsv=1e9 csv=1e9

Vdd vdd 0 dc 3.3
Vcm vinp 0 dc 1.65 ac {acp}
Ibias vdd ibias dc 10u
Xdut vdd 0 vinp vinn vout ibias opamp_two_stage
Esb vsb 0 vout 0 1
Rsv vsb vsv {rsv}
Csv vsv 0 {csv}
Esv vinn vnac vsv 0 1
Vnac vnac 0 dc 0 ac {acn}
CL vout 0 2p
