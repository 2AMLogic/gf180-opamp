* klt sim -- generated corner deck, do not edit
.lib /home/ubuntu/.volare/gf180mcuD/libs.tech/ngspice/sm141064.ngspice typical
.lib /home/ubuntu/.volare/gf180mcuD/libs.tech/ngspice/sm141064.ngspice res_typical
.lib /home/ubuntu/.volare/gf180mcuD/libs.tech/ngspice/sm141064.ngspice mimcap_typical
.include /tmp/noise-6r7zcukh/iso_lfb1e+10/tb.spice
.temp 27.0
.control
save all
alter vcm=1.65
alter vdd=3.3
set filetype=ascii
noise v(vout) Vcm dec 20 0.1 1e+07
print noise2.inoise_total noise2.onoise_total
setplot noise1
write /tmp/noise-6r7zcukh/iso_lfb1e+10/out/typical_vcm1p650_vdd3p300V_27C/waveform.raw
quit
.endc
.end
