* klt sim -- generated corner deck, do not edit
.lib /opt/pdk/gf180mcuD/libs.tech/ngspice/sm141064.ngspice sf
.lib /opt/pdk/gf180mcuD/libs.tech/ngspice/sm141064.ngspice res_typical
.lib /opt/pdk/gf180mcuD/libs.tech/ngspice/sm141064.ngspice mimcap_typical
.include /var/tmp/eda-job-klt-sim-92d2496e6052/inputs/netlist.cir
.temp 125.0
.control
save all
alter vcm=1.65
alter vdd=3.3
set filetype=ascii
noise v(vout) Vcm dec 20 0.1 1e+07
print noise2.inoise_total noise2.onoise_total
setplot noise1
write /var/tmp/eda-job-klt-sim-92d2496e6052/outputs/artifacts/sf_vcm1p650_vdd3p300V_125C/waveform.raw
quit
.endc
.end
