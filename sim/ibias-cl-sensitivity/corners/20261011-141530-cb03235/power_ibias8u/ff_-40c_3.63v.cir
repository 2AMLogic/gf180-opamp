* klt sim -- generated corner deck, do not edit
.lib /opt/pdk/gf180mcuD/libs.tech/ngspice/sm141064.ngspice ff
.lib /opt/pdk/gf180mcuD/libs.tech/ngspice/sm141064.ngspice res_typical
.lib /opt/pdk/gf180mcuD/libs.tech/ngspice/sm141064.ngspice mimcap_typical
.include /var/tmp/eda-job-klt-sim-8c09330413dc/inputs/netlist.cir
.temp -40.0
.meas dc ivdd_a FIND i(vdd) AT=8e-06
.meas dc vout_v FIND v(vout) AT=8e-06
.control
alter vcm=1.815
alter vdd=3.63
set filetype=ascii
dc Ibias 8e-06 9e-06 1u
write /var/tmp/eda-job-klt-sim-8c09330413dc/outputs/artifacts/ff_vcm1p815_vdd3p630V_n40C/waveform.raw
quit
.endc
.end
