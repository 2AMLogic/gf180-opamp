* klt sim -- generated corner deck, do not edit
.lib /opt/pdk/gf180mcuD/libs.tech/ngspice/sm141064.ngspice ss
.lib /opt/pdk/gf180mcuD/libs.tech/ngspice/sm141064.ngspice res_typical
.lib /opt/pdk/gf180mcuD/libs.tech/ngspice/sm141064.ngspice mimcap_typical
.include /var/tmp/eda-job-klt-sim-55a8beed70bf/inputs/netlist.cir
.temp 125.0
.meas dc ivdd_a FIND i(vdd) AT=9e-06
.meas dc vout_v FIND v(vout) AT=9e-06
.control
alter vcm=1.485
alter vdd=2.97
set filetype=ascii
dc Ibias 9e-06 1e-05 1u
write /var/tmp/eda-job-klt-sim-55a8beed70bf/outputs/artifacts/ss_vcm1p485_vdd2p970V_125C/waveform.raw
quit
.endc
.end
