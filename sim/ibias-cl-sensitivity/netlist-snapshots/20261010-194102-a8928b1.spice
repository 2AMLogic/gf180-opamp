* netlist snapshot for record 20261010-194102-a8928b1 (issue #114, ibias / CL sensitivity)
* ---- conditions: klt sim request (ac_ibias8u_cl2p) ----
* {
*  "engine": "ngspice",
*  "models": {
*   "pdk": "gf180mcuD",
*   "lib": "libs.tech/ngspice/sm141064.ngspice"
*  },
*  "corners": {
*   "process": [
*    {
*     "name": "typical",
*     "sections": [
*      "typical",
*      "res_typical",
*      "mimcap_typical"
*     ]
*    },
*    {
*     "name": "fs",
*     "sections": [
*      "fs",
*      "res_typical",
*      "mimcap_typical"
*     ]
*    },
*    {
*     "name": "ss",
*     "sections": [
*      "ss",
*      "res_typical",
*      "mimcap_typical"
*     ]
*    }
*   ],
*   "supply_v": {
*    "vdd": [
*     2.97,
*     3.3
*    ],
*    "vcm": [
*     1.485,
*     1.65
*    ]
*   },
*   "temperature_c": [
*    27.0,
*    125.0
*   ]
*  },
*  "analysis": {
*   "kind": "ac",
*   "args": "dec 20 0.1 1e+09"
*  },
*  "measurements": [
*   {
*    "name": "a_first_db",
*    "spice": ".meas ac a_first_db FIND vdb(vout) AT=0.1",
*    "unit": "dB"
*   },
*   {
*    "name": "gbw_hz",
*    "spice": ".meas ac gbw_hz WHEN vdb(vout)=0 FALL=1",
*    "unit": "Hz"
*   },
*   {
*    "name": "ph_gbw_rad",
*    "spice": ".meas ac ph_gbw_rad FIND vp(vout) WHEN vdb(vout)=0 FALL=1",
*    "unit": "rad"
*   }
*  ],
*  "options": {
*   "timeout_s": 300,
*   "keep_artifacts": true,
*   "waveforms": true
*  },
*  "exclude": [
*   {
*    "process": "typical",
*    "temperature_c": 27.0,
*    "supply_v": {
*     "vdd": 2.97
*    }
*   },
*   {
*    "process": "typical",
*    "temperature_c": 125.0,
*    "supply_v": {
*     "vdd": 2.97
*    }
*   },
*   {
*    "process": "typical",
*    "temperature_c": 125.0,
*    "supply_v": {
*     "vdd": 3.3
*    }
*   },
*   {
*    "process": "fs",
*    "temperature_c": 27.0,
*    "supply_v": {
*     "vdd": 2.97
*    }
*   },
*   {
*    "process": "fs",
*    "temperature_c": 27.0,
*    "supply_v": {
*     "vdd": 3.3
*    }
*   },
*   {
*    "process": "fs",
*    "temperature_c": 125.0,
*    "supply_v": {
*     "vdd": 3.3
*    }
*   },
*   {
*    "process": "ss",
*    "temperature_c": 27.0,
*    "supply_v": {
*     "vdd": 2.97
*    }
*   },
*   {
*    "process": "ss",
*    "temperature_c": 27.0,
*    "supply_v": {
*     "vdd": 3.3
*    }
*   },
*   {
*    "process": "ss",
*    "temperature_c": 125.0,
*    "supply_v": {
*     "vdd": 3.3
*    }
*   }
*  ],
*  "batch": {
*   "runner_version_check": "warn"
*  }
* }
* ---- conditions: klt sim request (power_ibias8u) ----
* {
*  "engine": "ngspice",
*  "models": {
*   "pdk": "gf180mcuD",
*   "lib": "libs.tech/ngspice/sm141064.ngspice"
*  },
*  "corners": {
*   "process": [
*    {
*     "name": "typical",
*     "sections": [
*      "typical",
*      "res_typical",
*      "mimcap_typical"
*     ]
*    },
*    {
*     "name": "ff",
*     "sections": [
*      "ff",
*      "res_typical",
*      "mimcap_typical"
*     ]
*    },
*    {
*     "name": "ss",
*     "sections": [
*      "ss",
*      "res_typical",
*      "mimcap_typical"
*     ]
*    }
*   ],
*   "supply_v": {
*    "vdd": [
*     2.97,
*     3.3,
*     3.63
*    ],
*    "vcm": [
*     1.485,
*     1.65,
*     1.815
*    ]
*   },
*   "temperature_c": [
*    -40.0,
*    27.0,
*    125.0
*   ]
*  },
*  "analysis": {
*   "kind": "dc",
*   "args": "Ibias 8e-06 9e-06 1u"
*  },
*  "measurements": [
*   {
*    "name": "ivdd_a",
*    "spice": ".meas dc ivdd_a FIND i(vdd) AT=8e-06",
*    "unit": "A"
*   },
*   {
*    "name": "vout_v",
*    "spice": ".meas dc vout_v FIND v(vout) AT=8e-06",
*    "unit": "V"
*   }
*  ],
*  "options": {
*   "timeout_s": 600,
*   "keep_artifacts": true,
*   "waveforms": true
*  },
*  "exclude": [
*   {
*    "process": "typical",
*    "temperature_c": -40.0,
*    "supply_v": {
*     "vdd": 2.97
*    }
*   },
*   {
*    "process": "typical",
*    "temperature_c": -40.0,
*    "supply_v": {
*     "vdd": 3.3
*    }
*   },
*   {
*    "process": "typical",
*    "temperature_c": -40.0,
*    "supply_v": {
*     "vdd": 3.63
*    }
*   },
*   {
*    "process": "typical",
*    "temperature_c": 27.0,
*    "supply_v": {
*     "vdd": 2.97
*    }
*   },
*   {
*    "process": "typical",
*    "temperature_c": 27.0,
*    "supply_v": {
*     "vdd": 3.63
*    }
*   },
*   {
*    "process": "typical",
*    "temperature_c": 125.0,
*    "supply_v": {
*     "vdd": 2.97
*    }
*   },
*   {
*    "process": "typical",
*    "temperature_c": 125.0,
*    "supply_v": {
*     "vdd": 3.3
*    }
*   },
*   {
*    "process": "typical",
*    "temperature_c": 125.0,
*    "supply_v": {
*     "vdd": 3.63
*    }
*   },
*   {
*    "process": "ff",
*    "temperature_c": -40.0,
*    "supply_v": {
*     "vdd": 2.97
*    }
*   },
*   {
*    "process": "ff",
*    "temperature_c": -40.0,
*    "supply_v": {
*     "vdd": 3.3
*    }
*   },
*   {
*    "process": "ff",
*    "temperature_c": 27.0,
*    "supply_v": {
*     "vdd": 2.97
*    }
*   },
*   {
*    "process": "ff",
*    "temperature_c": 27.0,
*    "supply_v": {
*     "vdd": 3.3
*    }
*   },
*   {
*    "process": "ff",
*    "temperature_c": 27.0,
*    "supply_v": {
*     "vdd": 3.63
*    }
*   },
*   {
*    "process": "ff",
*    "temperature_c": 125.0,
*    "supply_v": {
*     "vdd": 2.97
*    }
*   },
*   {
*    "process": "ff",
*    "temperature_c": 125.0,
*    "supply_v": {
*     "vdd": 3.3
*    }
*   },
*   {
*    "process": "ff",
*    "temperature_c": 125.0,
*    "supply_v": {
*     "vdd": 3.63
*    }
*   },
*   {
*    "process": "ss",
*    "temperature_c": -40.0,
*    "supply_v": {
*     "vdd": 2.97
*    }
*   },
*   {
*    "process": "ss",
*    "temperature_c": -40.0,
*    "supply_v": {
*     "vdd": 3.3
*    }
*   },
*   {
*    "process": "ss",
*    "temperature_c": -40.0,
*    "supply_v": {
*     "vdd": 3.63
*    }
*   },
*   {
*    "process": "ss",
*    "temperature_c": 27.0,
*    "supply_v": {
*     "vdd": 2.97
*    }
*   },
*   {
*    "process": "ss",
*    "temperature_c": 27.0,
*    "supply_v": {
*     "vdd": 3.3
*    }
*   },
*   {
*    "process": "ss",
*    "temperature_c": 27.0,
*    "supply_v": {
*     "vdd": 3.63
*    }
*   },
*   {
*    "process": "ss",
*    "temperature_c": 125.0,
*    "supply_v": {
*     "vdd": 3.3
*    }
*   },
*   {
*    "process": "ss",
*    "temperature_c": 125.0,
*    "supply_v": {
*     "vdd": 3.63
*    }
*   }
*  ],
*  "batch": {
*   "runner_version_check": "warn"
*  }
* }
* ---- conditions: klt sim request (slew_ibias8u_cl2p) ----
* {
*  "engine": "ngspice",
*  "models": {
*   "pdk": "gf180mcuD",
*   "lib": "libs.tech/ngspice/sm141064.ngspice"
*  },
*  "corners": {
*   "process": [
*    {
*     "name": "typical",
*     "sections": [
*      "typical",
*      "res_typical",
*      "mimcap_typical"
*     ]
*    },
*    {
*     "name": "ff",
*     "sections": [
*      "ff",
*      "res_typical",
*      "mimcap_typical"
*     ]
*    },
*    {
*     "name": "ss",
*     "sections": [
*      "ss",
*      "res_typical",
*      "mimcap_typical"
*     ]
*    }
*   ],
*   "supply_v": {
*    "vdd": [
*     2.97,
*     3.3,
*     3.63
*    ],
*    "vcm": [
*     1.485,
*     1.65,
*     1.815
*    ]
*   },
*   "temperature_c": [
*    -40.0,
*    27.0,
*    125.0
*   ]
*  },
*  "analysis": {
*   "kind": "tran",
*   "args": "5e-09 5e-06"
*  },
*  "measurements": [
*   {
*    "name": "vlo_v",
*    "spice": ".meas tran vlo_v FIND v(vout) AT=9.9e-07",
*    "unit": "V"
*   },
*   {
*    "name": "vhi_v",
*    "spice": ".meas tran vhi_v FIND v(vout) AT=2.99e-06",
*    "unit": "V"
*   }
*  ],
*  "options": {
*   "timeout_s": 600,
*   "keep_artifacts": true,
*   "waveforms": true
*  },
*  "exclude": [
*   {
*    "process": "typical",
*    "temperature_c": -40.0,
*    "supply_v": {
*     "vdd": 2.97
*    }
*   },
*   {
*    "process": "typical",
*    "temperature_c": -40.0,
*    "supply_v": {
*     "vdd": 3.3
*    }
*   },
*   {
*    "process": "typical",
*    "temperature_c": -40.0,
*    "supply_v": {
*     "vdd": 3.63
*    }
*   },
*   {
*    "process": "typical",
*    "temperature_c": 27.0,
*    "supply_v": {
*     "vdd": 2.97
*    }
*   },
*   {
*    "process": "typical",
*    "temperature_c": 27.0,
*    "supply_v": {
*     "vdd": 3.63
*    }
*   },
*   {
*    "process": "typical",
*    "temperature_c": 125.0,
*    "supply_v": {
*     "vdd": 2.97
*    }
*   },
*   {
*    "process": "typical",
*    "temperature_c": 125.0,
*    "supply_v": {
*     "vdd": 3.3
*    }
*   },
*   {
*    "process": "typical",
*    "temperature_c": 125.0,
*    "supply_v": {
*     "vdd": 3.63
*    }
*   },
*   {
*    "process": "ff",
*    "temperature_c": -40.0,
*    "supply_v": {
*     "vdd": 2.97
*    }
*   },
*   {
*    "process": "ff",
*    "temperature_c": -40.0,
*    "supply_v": {
*     "vdd": 3.3
*    }
*   },
*   {
*    "process": "ff",
*    "temperature_c": 27.0,
*    "supply_v": {
*     "vdd": 2.97
*    }
*   },
*   {
*    "process": "ff",
*    "temperature_c": 27.0,
*    "supply_v": {
*     "vdd": 3.3
*    }
*   },
*   {
*    "process": "ff",
*    "temperature_c": 27.0,
*    "supply_v": {
*     "vdd": 3.63
*    }
*   },
*   {
*    "process": "ff",
*    "temperature_c": 125.0,
*    "supply_v": {
*     "vdd": 2.97
*    }
*   },
*   {
*    "process": "ff",
*    "temperature_c": 125.0,
*    "supply_v": {
*     "vdd": 3.3
*    }
*   },
*   {
*    "process": "ff",
*    "temperature_c": 125.0,
*    "supply_v": {
*     "vdd": 3.63
*    }
*   },
*   {
*    "process": "ss",
*    "temperature_c": -40.0,
*    "supply_v": {
*     "vdd": 2.97
*    }
*   },
*   {
*    "process": "ss",
*    "temperature_c": -40.0,
*    "supply_v": {
*     "vdd": 3.3
*    }
*   },
*   {
*    "process": "ss",
*    "temperature_c": -40.0,
*    "supply_v": {
*     "vdd": 3.63
*    }
*   },
*   {
*    "process": "ss",
*    "temperature_c": 27.0,
*    "supply_v": {
*     "vdd": 2.97
*    }
*   },
*   {
*    "process": "ss",
*    "temperature_c": 27.0,
*    "supply_v": {
*     "vdd": 3.3
*    }
*   },
*   {
*    "process": "ss",
*    "temperature_c": 27.0,
*    "supply_v": {
*     "vdd": 3.63
*    }
*   },
*   {
*    "process": "ss",
*    "temperature_c": 125.0,
*    "supply_v": {
*     "vdd": 3.3
*    }
*   },
*   {
*    "process": "ss",
*    "temperature_c": 125.0,
*    "supply_v": {
*     "vdd": 3.63
*    }
*   }
*  ],
*  "batch": {
*   "runner_version_check": "warn"
*  }
* }
* ---- conditions: klt sim request (ac_ibias9u_cl2p) ----
* {
*  "engine": "ngspice",
*  "models": {
*   "pdk": "gf180mcuD",
*   "lib": "libs.tech/ngspice/sm141064.ngspice"
*  },
*  "corners": {
*   "process": [
*    {
*     "name": "typical",
*     "sections": [
*      "typical",
*      "res_typical",
*      "mimcap_typical"
*     ]
*    },
*    {
*     "name": "fs",
*     "sections": [
*      "fs",
*      "res_typical",
*      "mimcap_typical"
*     ]
*    },
*    {
*     "name": "ss",
*     "sections": [
*      "ss",
*      "res_typical",
*      "mimcap_typical"
*     ]
*    }
*   ],
*   "supply_v": {
*    "vdd": [
*     2.97,
*     3.3
*    ],
*    "vcm": [
*     1.485,
*     1.65
*    ]
*   },
*   "temperature_c": [
*    27.0,
*    125.0
*   ]
*  },
*  "analysis": {
*   "kind": "ac",
*   "args": "dec 20 0.1 1e+09"
*  },
*  "measurements": [
*   {
*    "name": "a_first_db",
*    "spice": ".meas ac a_first_db FIND vdb(vout) AT=0.1",
*    "unit": "dB"
*   },
*   {
*    "name": "gbw_hz",
*    "spice": ".meas ac gbw_hz WHEN vdb(vout)=0 FALL=1",
*    "unit": "Hz"
*   },
*   {
*    "name": "ph_gbw_rad",
*    "spice": ".meas ac ph_gbw_rad FIND vp(vout) WHEN vdb(vout)=0 FALL=1",
*    "unit": "rad"
*   }
*  ],
*  "options": {
*   "timeout_s": 300,
*   "keep_artifacts": true,
*   "waveforms": true
*  },
*  "exclude": [
*   {
*    "process": "typical",
*    "temperature_c": 27.0,
*    "supply_v": {
*     "vdd": 2.97
*    }
*   },
*   {
*    "process": "typical",
*    "temperature_c": 125.0,
*    "supply_v": {
*     "vdd": 2.97
*    }
*   },
*   {
*    "process": "typical",
*    "temperature_c": 125.0,
*    "supply_v": {
*     "vdd": 3.3
*    }
*   },
*   {
*    "process": "fs",
*    "temperature_c": 27.0,
*    "supply_v": {
*     "vdd": 2.97
*    }
*   },
*   {
*    "process": "fs",
*    "temperature_c": 27.0,
*    "supply_v": {
*     "vdd": 3.3
*    }
*   },
*   {
*    "process": "fs",
*    "temperature_c": 125.0,
*    "supply_v": {
*     "vdd": 3.3
*    }
*   },
*   {
*    "process": "ss",
*    "temperature_c": 27.0,
*    "supply_v": {
*     "vdd": 2.97
*    }
*   },
*   {
*    "process": "ss",
*    "temperature_c": 27.0,
*    "supply_v": {
*     "vdd": 3.3
*    }
*   },
*   {
*    "process": "ss",
*    "temperature_c": 125.0,
*    "supply_v": {
*     "vdd": 3.3
*    }
*   }
*  ],
*  "batch": {
*   "runner_version_check": "warn"
*  }
* }
* ---- conditions: klt sim request (power_ibias9u) ----
* {
*  "engine": "ngspice",
*  "models": {
*   "pdk": "gf180mcuD",
*   "lib": "libs.tech/ngspice/sm141064.ngspice"
*  },
*  "corners": {
*   "process": [
*    {
*     "name": "typical",
*     "sections": [
*      "typical",
*      "res_typical",
*      "mimcap_typical"
*     ]
*    },
*    {
*     "name": "ff",
*     "sections": [
*      "ff",
*      "res_typical",
*      "mimcap_typical"
*     ]
*    },
*    {
*     "name": "ss",
*     "sections": [
*      "ss",
*      "res_typical",
*      "mimcap_typical"
*     ]
*    }
*   ],
*   "supply_v": {
*    "vdd": [
*     2.97,
*     3.3,
*     3.63
*    ],
*    "vcm": [
*     1.485,
*     1.65,
*     1.815
*    ]
*   },
*   "temperature_c": [
*    -40.0,
*    27.0,
*    125.0
*   ]
*  },
*  "analysis": {
*   "kind": "dc",
*   "args": "Ibias 9e-06 1e-05 1u"
*  },
*  "measurements": [
*   {
*    "name": "ivdd_a",
*    "spice": ".meas dc ivdd_a FIND i(vdd) AT=9e-06",
*    "unit": "A"
*   },
*   {
*    "name": "vout_v",
*    "spice": ".meas dc vout_v FIND v(vout) AT=9e-06",
*    "unit": "V"
*   }
*  ],
*  "options": {
*   "timeout_s": 600,
*   "keep_artifacts": true,
*   "waveforms": true
*  },
*  "exclude": [
*   {
*    "process": "typical",
*    "temperature_c": -40.0,
*    "supply_v": {
*     "vdd": 2.97
*    }
*   },
*   {
*    "process": "typical",
*    "temperature_c": -40.0,
*    "supply_v": {
*     "vdd": 3.3
*    }
*   },
*   {
*    "process": "typical",
*    "temperature_c": -40.0,
*    "supply_v": {
*     "vdd": 3.63
*    }
*   },
*   {
*    "process": "typical",
*    "temperature_c": 27.0,
*    "supply_v": {
*     "vdd": 2.97
*    }
*   },
*   {
*    "process": "typical",
*    "temperature_c": 27.0,
*    "supply_v": {
*     "vdd": 3.63
*    }
*   },
*   {
*    "process": "typical",
*    "temperature_c": 125.0,
*    "supply_v": {
*     "vdd": 2.97
*    }
*   },
*   {
*    "process": "typical",
*    "temperature_c": 125.0,
*    "supply_v": {
*     "vdd": 3.3
*    }
*   },
*   {
*    "process": "typical",
*    "temperature_c": 125.0,
*    "supply_v": {
*     "vdd": 3.63
*    }
*   },
*   {
*    "process": "ff",
*    "temperature_c": -40.0,
*    "supply_v": {
*     "vdd": 2.97
*    }
*   },
*   {
*    "process": "ff",
*    "temperature_c": -40.0,
*    "supply_v": {
*     "vdd": 3.3
*    }
*   },
*   {
*    "process": "ff",
*    "temperature_c": 27.0,
*    "supply_v": {
*     "vdd": 2.97
*    }
*   },
*   {
*    "process": "ff",
*    "temperature_c": 27.0,
*    "supply_v": {
*     "vdd": 3.3
*    }
*   },
*   {
*    "process": "ff",
*    "temperature_c": 27.0,
*    "supply_v": {
*     "vdd": 3.63
*    }
*   },
*   {
*    "process": "ff",
*    "temperature_c": 125.0,
*    "supply_v": {
*     "vdd": 2.97
*    }
*   },
*   {
*    "process": "ff",
*    "temperature_c": 125.0,
*    "supply_v": {
*     "vdd": 3.3
*    }
*   },
*   {
*    "process": "ff",
*    "temperature_c": 125.0,
*    "supply_v": {
*     "vdd": 3.63
*    }
*   },
*   {
*    "process": "ss",
*    "temperature_c": -40.0,
*    "supply_v": {
*     "vdd": 2.97
*    }
*   },
*   {
*    "process": "ss",
*    "temperature_c": -40.0,
*    "supply_v": {
*     "vdd": 3.3
*    }
*   },
*   {
*    "process": "ss",
*    "temperature_c": -40.0,
*    "supply_v": {
*     "vdd": 3.63
*    }
*   },
*   {
*    "process": "ss",
*    "temperature_c": 27.0,
*    "supply_v": {
*     "vdd": 2.97
*    }
*   },
*   {
*    "process": "ss",
*    "temperature_c": 27.0,
*    "supply_v": {
*     "vdd": 3.3
*    }
*   },
*   {
*    "process": "ss",
*    "temperature_c": 27.0,
*    "supply_v": {
*     "vdd": 3.63
*    }
*   },
*   {
*    "process": "ss",
*    "temperature_c": 125.0,
*    "supply_v": {
*     "vdd": 3.3
*    }
*   },
*   {
*    "process": "ss",
*    "temperature_c": 125.0,
*    "supply_v": {
*     "vdd": 3.63
*    }
*   }
*  ],
*  "batch": {
*   "runner_version_check": "warn"
*  }
* }
* ---- conditions: klt sim request (slew_ibias9u_cl2p) ----
* {
*  "engine": "ngspice",
*  "models": {
*   "pdk": "gf180mcuD",
*   "lib": "libs.tech/ngspice/sm141064.ngspice"
*  },
*  "corners": {
*   "process": [
*    {
*     "name": "typical",
*     "sections": [
*      "typical",
*      "res_typical",
*      "mimcap_typical"
*     ]
*    },
*    {
*     "name": "ff",
*     "sections": [
*      "ff",
*      "res_typical",
*      "mimcap_typical"
*     ]
*    },
*    {
*     "name": "ss",
*     "sections": [
*      "ss",
*      "res_typical",
*      "mimcap_typical"
*     ]
*    }
*   ],
*   "supply_v": {
*    "vdd": [
*     2.97,
*     3.3,
*     3.63
*    ],
*    "vcm": [
*     1.485,
*     1.65,
*     1.815
*    ]
*   },
*   "temperature_c": [
*    -40.0,
*    27.0,
*    125.0
*   ]
*  },
*  "analysis": {
*   "kind": "tran",
*   "args": "5e-09 5e-06"
*  },
*  "measurements": [
*   {
*    "name": "vlo_v",
*    "spice": ".meas tran vlo_v FIND v(vout) AT=9.9e-07",
*    "unit": "V"
*   },
*   {
*    "name": "vhi_v",
*    "spice": ".meas tran vhi_v FIND v(vout) AT=2.99e-06",
*    "unit": "V"
*   }
*  ],
*  "options": {
*   "timeout_s": 600,
*   "keep_artifacts": true,
*   "waveforms": true
*  },
*  "exclude": [
*   {
*    "process": "typical",
*    "temperature_c": -40.0,
*    "supply_v": {
*     "vdd": 2.97
*    }
*   },
*   {
*    "process": "typical",
*    "temperature_c": -40.0,
*    "supply_v": {
*     "vdd": 3.3
*    }
*   },
*   {
*    "process": "typical",
*    "temperature_c": -40.0,
*    "supply_v": {
*     "vdd": 3.63
*    }
*   },
*   {
*    "process": "typical",
*    "temperature_c": 27.0,
*    "supply_v": {
*     "vdd": 2.97
*    }
*   },
*   {
*    "process": "typical",
*    "temperature_c": 27.0,
*    "supply_v": {
*     "vdd": 3.63
*    }
*   },
*   {
*    "process": "typical",
*    "temperature_c": 125.0,
*    "supply_v": {
*     "vdd": 2.97
*    }
*   },
*   {
*    "process": "typical",
*    "temperature_c": 125.0,
*    "supply_v": {
*     "vdd": 3.3
*    }
*   },
*   {
*    "process": "typical",
*    "temperature_c": 125.0,
*    "supply_v": {
*     "vdd": 3.63
*    }
*   },
*   {
*    "process": "ff",
*    "temperature_c": -40.0,
*    "supply_v": {
*     "vdd": 2.97
*    }
*   },
*   {
*    "process": "ff",
*    "temperature_c": -40.0,
*    "supply_v": {
*     "vdd": 3.3
*    }
*   },
*   {
*    "process": "ff",
*    "temperature_c": 27.0,
*    "supply_v": {
*     "vdd": 2.97
*    }
*   },
*   {
*    "process": "ff",
*    "temperature_c": 27.0,
*    "supply_v": {
*     "vdd": 3.3
*    }
*   },
*   {
*    "process": "ff",
*    "temperature_c": 27.0,
*    "supply_v": {
*     "vdd": 3.63
*    }
*   },
*   {
*    "process": "ff",
*    "temperature_c": 125.0,
*    "supply_v": {
*     "vdd": 2.97
*    }
*   },
*   {
*    "process": "ff",
*    "temperature_c": 125.0,
*    "supply_v": {
*     "vdd": 3.3
*    }
*   },
*   {
*    "process": "ff",
*    "temperature_c": 125.0,
*    "supply_v": {
*     "vdd": 3.63
*    }
*   },
*   {
*    "process": "ss",
*    "temperature_c": -40.0,
*    "supply_v": {
*     "vdd": 2.97
*    }
*   },
*   {
*    "process": "ss",
*    "temperature_c": -40.0,
*    "supply_v": {
*     "vdd": 3.3
*    }
*   },
*   {
*    "process": "ss",
*    "temperature_c": -40.0,
*    "supply_v": {
*     "vdd": 3.63
*    }
*   },
*   {
*    "process": "ss",
*    "temperature_c": 27.0,
*    "supply_v": {
*     "vdd": 2.97
*    }
*   },
*   {
*    "process": "ss",
*    "temperature_c": 27.0,
*    "supply_v": {
*     "vdd": 3.3
*    }
*   },
*   {
*    "process": "ss",
*    "temperature_c": 27.0,
*    "supply_v": {
*     "vdd": 3.63
*    }
*   },
*   {
*    "process": "ss",
*    "temperature_c": 125.0,
*    "supply_v": {
*     "vdd": 3.3
*    }
*   },
*   {
*    "process": "ss",
*    "temperature_c": 125.0,
*    "supply_v": {
*     "vdd": 3.63
*    }
*   }
*  ],
*  "batch": {
*   "runner_version_check": "warn"
*  }
* }
* ---- conditions: klt sim request (ac_ibias10u_cl2p) ----
* {
*  "engine": "ngspice",
*  "models": {
*   "pdk": "gf180mcuD",
*   "lib": "libs.tech/ngspice/sm141064.ngspice"
*  },
*  "corners": {
*   "process": [
*    {
*     "name": "typical",
*     "sections": [
*      "typical",
*      "res_typical",
*      "mimcap_typical"
*     ]
*    },
*    {
*     "name": "fs",
*     "sections": [
*      "fs",
*      "res_typical",
*      "mimcap_typical"
*     ]
*    },
*    {
*     "name": "ss",
*     "sections": [
*      "ss",
*      "res_typical",
*      "mimcap_typical"
*     ]
*    }
*   ],
*   "supply_v": {
*    "vdd": [
*     2.97,
*     3.3
*    ],
*    "vcm": [
*     1.485,
*     1.65
*    ]
*   },
*   "temperature_c": [
*    27.0,
*    125.0
*   ]
*  },
*  "analysis": {
*   "kind": "ac",
*   "args": "dec 20 0.1 1e+09"
*  },
*  "measurements": [
*   {
*    "name": "a_first_db",
*    "spice": ".meas ac a_first_db FIND vdb(vout) AT=0.1",
*    "unit": "dB"
*   },
*   {
*    "name": "gbw_hz",
*    "spice": ".meas ac gbw_hz WHEN vdb(vout)=0 FALL=1",
*    "unit": "Hz"
*   },
*   {
*    "name": "ph_gbw_rad",
*    "spice": ".meas ac ph_gbw_rad FIND vp(vout) WHEN vdb(vout)=0 FALL=1",
*    "unit": "rad"
*   }
*  ],
*  "options": {
*   "timeout_s": 300,
*   "keep_artifacts": true,
*   "waveforms": true
*  },
*  "exclude": [
*   {
*    "process": "typical",
*    "temperature_c": 27.0,
*    "supply_v": {
*     "vdd": 2.97
*    }
*   },
*   {
*    "process": "typical",
*    "temperature_c": 125.0,
*    "supply_v": {
*     "vdd": 2.97
*    }
*   },
*   {
*    "process": "typical",
*    "temperature_c": 125.0,
*    "supply_v": {
*     "vdd": 3.3
*    }
*   },
*   {
*    "process": "fs",
*    "temperature_c": 27.0,
*    "supply_v": {
*     "vdd": 2.97
*    }
*   },
*   {
*    "process": "fs",
*    "temperature_c": 27.0,
*    "supply_v": {
*     "vdd": 3.3
*    }
*   },
*   {
*    "process": "fs",
*    "temperature_c": 125.0,
*    "supply_v": {
*     "vdd": 3.3
*    }
*   },
*   {
*    "process": "ss",
*    "temperature_c": 27.0,
*    "supply_v": {
*     "vdd": 2.97
*    }
*   },
*   {
*    "process": "ss",
*    "temperature_c": 27.0,
*    "supply_v": {
*     "vdd": 3.3
*    }
*   },
*   {
*    "process": "ss",
*    "temperature_c": 125.0,
*    "supply_v": {
*     "vdd": 3.3
*    }
*   }
*  ],
*  "batch": {
*   "runner_version_check": "warn"
*  }
* }
* ---- conditions: klt sim request (power_ibias10u) ----
* {
*  "engine": "ngspice",
*  "models": {
*   "pdk": "gf180mcuD",
*   "lib": "libs.tech/ngspice/sm141064.ngspice"
*  },
*  "corners": {
*   "process": [
*    {
*     "name": "typical",
*     "sections": [
*      "typical",
*      "res_typical",
*      "mimcap_typical"
*     ]
*    },
*    {
*     "name": "ff",
*     "sections": [
*      "ff",
*      "res_typical",
*      "mimcap_typical"
*     ]
*    },
*    {
*     "name": "ss",
*     "sections": [
*      "ss",
*      "res_typical",
*      "mimcap_typical"
*     ]
*    }
*   ],
*   "supply_v": {
*    "vdd": [
*     2.97,
*     3.3,
*     3.63
*    ],
*    "vcm": [
*     1.485,
*     1.65,
*     1.815
*    ]
*   },
*   "temperature_c": [
*    -40.0,
*    27.0,
*    125.0
*   ]
*  },
*  "analysis": {
*   "kind": "dc",
*   "args": "Ibias 1e-05 1.1e-05 1u"
*  },
*  "measurements": [
*   {
*    "name": "ivdd_a",
*    "spice": ".meas dc ivdd_a FIND i(vdd) AT=1e-05",
*    "unit": "A"
*   },
*   {
*    "name": "vout_v",
*    "spice": ".meas dc vout_v FIND v(vout) AT=1e-05",
*    "unit": "V"
*   }
*  ],
*  "options": {
*   "timeout_s": 600,
*   "keep_artifacts": true,
*   "waveforms": true
*  },
*  "exclude": [
*   {
*    "process": "typical",
*    "temperature_c": -40.0,
*    "supply_v": {
*     "vdd": 2.97
*    }
*   },
*   {
*    "process": "typical",
*    "temperature_c": -40.0,
*    "supply_v": {
*     "vdd": 3.3
*    }
*   },
*   {
*    "process": "typical",
*    "temperature_c": -40.0,
*    "supply_v": {
*     "vdd": 3.63
*    }
*   },
*   {
*    "process": "typical",
*    "temperature_c": 27.0,
*    "supply_v": {
*     "vdd": 2.97
*    }
*   },
*   {
*    "process": "typical",
*    "temperature_c": 27.0,
*    "supply_v": {
*     "vdd": 3.63
*    }
*   },
*   {
*    "process": "typical",
*    "temperature_c": 125.0,
*    "supply_v": {
*     "vdd": 2.97
*    }
*   },
*   {
*    "process": "typical",
*    "temperature_c": 125.0,
*    "supply_v": {
*     "vdd": 3.3
*    }
*   },
*   {
*    "process": "typical",
*    "temperature_c": 125.0,
*    "supply_v": {
*     "vdd": 3.63
*    }
*   },
*   {
*    "process": "ff",
*    "temperature_c": -40.0,
*    "supply_v": {
*     "vdd": 2.97
*    }
*   },
*   {
*    "process": "ff",
*    "temperature_c": -40.0,
*    "supply_v": {
*     "vdd": 3.3
*    }
*   },
*   {
*    "process": "ff",
*    "temperature_c": 27.0,
*    "supply_v": {
*     "vdd": 2.97
*    }
*   },
*   {
*    "process": "ff",
*    "temperature_c": 27.0,
*    "supply_v": {
*     "vdd": 3.3
*    }
*   },
*   {
*    "process": "ff",
*    "temperature_c": 27.0,
*    "supply_v": {
*     "vdd": 3.63
*    }
*   },
*   {
*    "process": "ff",
*    "temperature_c": 125.0,
*    "supply_v": {
*     "vdd": 2.97
*    }
*   },
*   {
*    "process": "ff",
*    "temperature_c": 125.0,
*    "supply_v": {
*     "vdd": 3.3
*    }
*   },
*   {
*    "process": "ff",
*    "temperature_c": 125.0,
*    "supply_v": {
*     "vdd": 3.63
*    }
*   },
*   {
*    "process": "ss",
*    "temperature_c": -40.0,
*    "supply_v": {
*     "vdd": 2.97
*    }
*   },
*   {
*    "process": "ss",
*    "temperature_c": -40.0,
*    "supply_v": {
*     "vdd": 3.3
*    }
*   },
*   {
*    "process": "ss",
*    "temperature_c": -40.0,
*    "supply_v": {
*     "vdd": 3.63
*    }
*   },
*   {
*    "process": "ss",
*    "temperature_c": 27.0,
*    "supply_v": {
*     "vdd": 2.97
*    }
*   },
*   {
*    "process": "ss",
*    "temperature_c": 27.0,
*    "supply_v": {
*     "vdd": 3.3
*    }
*   },
*   {
*    "process": "ss",
*    "temperature_c": 27.0,
*    "supply_v": {
*     "vdd": 3.63
*    }
*   },
*   {
*    "process": "ss",
*    "temperature_c": 125.0,
*    "supply_v": {
*     "vdd": 3.3
*    }
*   },
*   {
*    "process": "ss",
*    "temperature_c": 125.0,
*    "supply_v": {
*     "vdd": 3.63
*    }
*   }
*  ],
*  "batch": {
*   "runner_version_check": "warn"
*  }
* }
* ---- conditions: klt sim request (slew_ibias10u_cl2p) ----
* {
*  "engine": "ngspice",
*  "models": {
*   "pdk": "gf180mcuD",
*   "lib": "libs.tech/ngspice/sm141064.ngspice"
*  },
*  "corners": {
*   "process": [
*    {
*     "name": "typical",
*     "sections": [
*      "typical",
*      "res_typical",
*      "mimcap_typical"
*     ]
*    },
*    {
*     "name": "ff",
*     "sections": [
*      "ff",
*      "res_typical",
*      "mimcap_typical"
*     ]
*    },
*    {
*     "name": "ss",
*     "sections": [
*      "ss",
*      "res_typical",
*      "mimcap_typical"
*     ]
*    }
*   ],
*   "supply_v": {
*    "vdd": [
*     2.97,
*     3.3,
*     3.63
*    ],
*    "vcm": [
*     1.485,
*     1.65,
*     1.815
*    ]
*   },
*   "temperature_c": [
*    -40.0,
*    27.0,
*    125.0
*   ]
*  },
*  "analysis": {
*   "kind": "tran",
*   "args": "5e-09 5e-06"
*  },
*  "measurements": [
*   {
*    "name": "vlo_v",
*    "spice": ".meas tran vlo_v FIND v(vout) AT=9.9e-07",
*    "unit": "V"
*   },
*   {
*    "name": "vhi_v",
*    "spice": ".meas tran vhi_v FIND v(vout) AT=2.99e-06",
*    "unit": "V"
*   }
*  ],
*  "options": {
*   "timeout_s": 600,
*   "keep_artifacts": true,
*   "waveforms": true
*  },
*  "exclude": [
*   {
*    "process": "typical",
*    "temperature_c": -40.0,
*    "supply_v": {
*     "vdd": 2.97
*    }
*   },
*   {
*    "process": "typical",
*    "temperature_c": -40.0,
*    "supply_v": {
*     "vdd": 3.3
*    }
*   },
*   {
*    "process": "typical",
*    "temperature_c": -40.0,
*    "supply_v": {
*     "vdd": 3.63
*    }
*   },
*   {
*    "process": "typical",
*    "temperature_c": 27.0,
*    "supply_v": {
*     "vdd": 2.97
*    }
*   },
*   {
*    "process": "typical",
*    "temperature_c": 27.0,
*    "supply_v": {
*     "vdd": 3.63
*    }
*   },
*   {
*    "process": "typical",
*    "temperature_c": 125.0,
*    "supply_v": {
*     "vdd": 2.97
*    }
*   },
*   {
*    "process": "typical",
*    "temperature_c": 125.0,
*    "supply_v": {
*     "vdd": 3.3
*    }
*   },
*   {
*    "process": "typical",
*    "temperature_c": 125.0,
*    "supply_v": {
*     "vdd": 3.63
*    }
*   },
*   {
*    "process": "ff",
*    "temperature_c": -40.0,
*    "supply_v": {
*     "vdd": 2.97
*    }
*   },
*   {
*    "process": "ff",
*    "temperature_c": -40.0,
*    "supply_v": {
*     "vdd": 3.3
*    }
*   },
*   {
*    "process": "ff",
*    "temperature_c": 27.0,
*    "supply_v": {
*     "vdd": 2.97
*    }
*   },
*   {
*    "process": "ff",
*    "temperature_c": 27.0,
*    "supply_v": {
*     "vdd": 3.3
*    }
*   },
*   {
*    "process": "ff",
*    "temperature_c": 27.0,
*    "supply_v": {
*     "vdd": 3.63
*    }
*   },
*   {
*    "process": "ff",
*    "temperature_c": 125.0,
*    "supply_v": {
*     "vdd": 2.97
*    }
*   },
*   {
*    "process": "ff",
*    "temperature_c": 125.0,
*    "supply_v": {
*     "vdd": 3.3
*    }
*   },
*   {
*    "process": "ff",
*    "temperature_c": 125.0,
*    "supply_v": {
*     "vdd": 3.63
*    }
*   },
*   {
*    "process": "ss",
*    "temperature_c": -40.0,
*    "supply_v": {
*     "vdd": 2.97
*    }
*   },
*   {
*    "process": "ss",
*    "temperature_c": -40.0,
*    "supply_v": {
*     "vdd": 3.3
*    }
*   },
*   {
*    "process": "ss",
*    "temperature_c": -40.0,
*    "supply_v": {
*     "vdd": 3.63
*    }
*   },
*   {
*    "process": "ss",
*    "temperature_c": 27.0,
*    "supply_v": {
*     "vdd": 2.97
*    }
*   },
*   {
*    "process": "ss",
*    "temperature_c": 27.0,
*    "supply_v": {
*     "vdd": 3.3
*    }
*   },
*   {
*    "process": "ss",
*    "temperature_c": 27.0,
*    "supply_v": {
*     "vdd": 3.63
*    }
*   },
*   {
*    "process": "ss",
*    "temperature_c": 125.0,
*    "supply_v": {
*     "vdd": 3.3
*    }
*   },
*   {
*    "process": "ss",
*    "temperature_c": 125.0,
*    "supply_v": {
*     "vdd": 3.63
*    }
*   }
*  ],
*  "batch": {
*   "runner_version_check": "warn"
*  }
* }
* ---- conditions: klt sim request (ac_ibias11u_cl2p) ----
* {
*  "engine": "ngspice",
*  "models": {
*   "pdk": "gf180mcuD",
*   "lib": "libs.tech/ngspice/sm141064.ngspice"
*  },
*  "corners": {
*   "process": [
*    {
*     "name": "typical",
*     "sections": [
*      "typical",
*      "res_typical",
*      "mimcap_typical"
*     ]
*    },
*    {
*     "name": "fs",
*     "sections": [
*      "fs",
*      "res_typical",
*      "mimcap_typical"
*     ]
*    },
*    {
*     "name": "ss",
*     "sections": [
*      "ss",
*      "res_typical",
*      "mimcap_typical"
*     ]
*    }
*   ],
*   "supply_v": {
*    "vdd": [
*     2.97,
*     3.3
*    ],
*    "vcm": [
*     1.485,
*     1.65
*    ]
*   },
*   "temperature_c": [
*    27.0,
*    125.0
*   ]
*  },
*  "analysis": {
*   "kind": "ac",
*   "args": "dec 20 0.1 1e+09"
*  },
*  "measurements": [
*   {
*    "name": "a_first_db",
*    "spice": ".meas ac a_first_db FIND vdb(vout) AT=0.1",
*    "unit": "dB"
*   },
*   {
*    "name": "gbw_hz",
*    "spice": ".meas ac gbw_hz WHEN vdb(vout)=0 FALL=1",
*    "unit": "Hz"
*   },
*   {
*    "name": "ph_gbw_rad",
*    "spice": ".meas ac ph_gbw_rad FIND vp(vout) WHEN vdb(vout)=0 FALL=1",
*    "unit": "rad"
*   }
*  ],
*  "options": {
*   "timeout_s": 300,
*   "keep_artifacts": true,
*   "waveforms": true
*  },
*  "exclude": [
*   {
*    "process": "typical",
*    "temperature_c": 27.0,
*    "supply_v": {
*     "vdd": 2.97
*    }
*   },
*   {
*    "process": "typical",
*    "temperature_c": 125.0,
*    "supply_v": {
*     "vdd": 2.97
*    }
*   },
*   {
*    "process": "typical",
*    "temperature_c": 125.0,
*    "supply_v": {
*     "vdd": 3.3
*    }
*   },
*   {
*    "process": "fs",
*    "temperature_c": 27.0,
*    "supply_v": {
*     "vdd": 2.97
*    }
*   },
*   {
*    "process": "fs",
*    "temperature_c": 27.0,
*    "supply_v": {
*     "vdd": 3.3
*    }
*   },
*   {
*    "process": "fs",
*    "temperature_c": 125.0,
*    "supply_v": {
*     "vdd": 3.3
*    }
*   },
*   {
*    "process": "ss",
*    "temperature_c": 27.0,
*    "supply_v": {
*     "vdd": 2.97
*    }
*   },
*   {
*    "process": "ss",
*    "temperature_c": 27.0,
*    "supply_v": {
*     "vdd": 3.3
*    }
*   },
*   {
*    "process": "ss",
*    "temperature_c": 125.0,
*    "supply_v": {
*     "vdd": 3.3
*    }
*   }
*  ],
*  "batch": {
*   "runner_version_check": "warn"
*  }
* }
* ---- conditions: klt sim request (power_ibias11u) ----
* {
*  "engine": "ngspice",
*  "models": {
*   "pdk": "gf180mcuD",
*   "lib": "libs.tech/ngspice/sm141064.ngspice"
*  },
*  "corners": {
*   "process": [
*    {
*     "name": "typical",
*     "sections": [
*      "typical",
*      "res_typical",
*      "mimcap_typical"
*     ]
*    },
*    {
*     "name": "ff",
*     "sections": [
*      "ff",
*      "res_typical",
*      "mimcap_typical"
*     ]
*    },
*    {
*     "name": "ss",
*     "sections": [
*      "ss",
*      "res_typical",
*      "mimcap_typical"
*     ]
*    }
*   ],
*   "supply_v": {
*    "vdd": [
*     2.97,
*     3.3,
*     3.63
*    ],
*    "vcm": [
*     1.485,
*     1.65,
*     1.815
*    ]
*   },
*   "temperature_c": [
*    -40.0,
*    27.0,
*    125.0
*   ]
*  },
*  "analysis": {
*   "kind": "dc",
*   "args": "Ibias 1.1e-05 1.2e-05 1u"
*  },
*  "measurements": [
*   {
*    "name": "ivdd_a",
*    "spice": ".meas dc ivdd_a FIND i(vdd) AT=1.1e-05",
*    "unit": "A"
*   },
*   {
*    "name": "vout_v",
*    "spice": ".meas dc vout_v FIND v(vout) AT=1.1e-05",
*    "unit": "V"
*   }
*  ],
*  "options": {
*   "timeout_s": 600,
*   "keep_artifacts": true,
*   "waveforms": true
*  },
*  "exclude": [
*   {
*    "process": "typical",
*    "temperature_c": -40.0,
*    "supply_v": {
*     "vdd": 2.97
*    }
*   },
*   {
*    "process": "typical",
*    "temperature_c": -40.0,
*    "supply_v": {
*     "vdd": 3.3
*    }
*   },
*   {
*    "process": "typical",
*    "temperature_c": -40.0,
*    "supply_v": {
*     "vdd": 3.63
*    }
*   },
*   {
*    "process": "typical",
*    "temperature_c": 27.0,
*    "supply_v": {
*     "vdd": 2.97
*    }
*   },
*   {
*    "process": "typical",
*    "temperature_c": 27.0,
*    "supply_v": {
*     "vdd": 3.63
*    }
*   },
*   {
*    "process": "typical",
*    "temperature_c": 125.0,
*    "supply_v": {
*     "vdd": 2.97
*    }
*   },
*   {
*    "process": "typical",
*    "temperature_c": 125.0,
*    "supply_v": {
*     "vdd": 3.3
*    }
*   },
*   {
*    "process": "typical",
*    "temperature_c": 125.0,
*    "supply_v": {
*     "vdd": 3.63
*    }
*   },
*   {
*    "process": "ff",
*    "temperature_c": -40.0,
*    "supply_v": {
*     "vdd": 2.97
*    }
*   },
*   {
*    "process": "ff",
*    "temperature_c": -40.0,
*    "supply_v": {
*     "vdd": 3.3
*    }
*   },
*   {
*    "process": "ff",
*    "temperature_c": 27.0,
*    "supply_v": {
*     "vdd": 2.97
*    }
*   },
*   {
*    "process": "ff",
*    "temperature_c": 27.0,
*    "supply_v": {
*     "vdd": 3.3
*    }
*   },
*   {
*    "process": "ff",
*    "temperature_c": 27.0,
*    "supply_v": {
*     "vdd": 3.63
*    }
*   },
*   {
*    "process": "ff",
*    "temperature_c": 125.0,
*    "supply_v": {
*     "vdd": 2.97
*    }
*   },
*   {
*    "process": "ff",
*    "temperature_c": 125.0,
*    "supply_v": {
*     "vdd": 3.3
*    }
*   },
*   {
*    "process": "ff",
*    "temperature_c": 125.0,
*    "supply_v": {
*     "vdd": 3.63
*    }
*   },
*   {
*    "process": "ss",
*    "temperature_c": -40.0,
*    "supply_v": {
*     "vdd": 2.97
*    }
*   },
*   {
*    "process": "ss",
*    "temperature_c": -40.0,
*    "supply_v": {
*     "vdd": 3.3
*    }
*   },
*   {
*    "process": "ss",
*    "temperature_c": -40.0,
*    "supply_v": {
*     "vdd": 3.63
*    }
*   },
*   {
*    "process": "ss",
*    "temperature_c": 27.0,
*    "supply_v": {
*     "vdd": 2.97
*    }
*   },
*   {
*    "process": "ss",
*    "temperature_c": 27.0,
*    "supply_v": {
*     "vdd": 3.3
*    }
*   },
*   {
*    "process": "ss",
*    "temperature_c": 27.0,
*    "supply_v": {
*     "vdd": 3.63
*    }
*   },
*   {
*    "process": "ss",
*    "temperature_c": 125.0,
*    "supply_v": {
*     "vdd": 3.3
*    }
*   },
*   {
*    "process": "ss",
*    "temperature_c": 125.0,
*    "supply_v": {
*     "vdd": 3.63
*    }
*   }
*  ],
*  "batch": {
*   "runner_version_check": "warn"
*  }
* }
* ---- conditions: klt sim request (slew_ibias11u_cl2p) ----
* {
*  "engine": "ngspice",
*  "models": {
*   "pdk": "gf180mcuD",
*   "lib": "libs.tech/ngspice/sm141064.ngspice"
*  },
*  "corners": {
*   "process": [
*    {
*     "name": "typical",
*     "sections": [
*      "typical",
*      "res_typical",
*      "mimcap_typical"
*     ]
*    },
*    {
*     "name": "ff",
*     "sections": [
*      "ff",
*      "res_typical",
*      "mimcap_typical"
*     ]
*    },
*    {
*     "name": "ss",
*     "sections": [
*      "ss",
*      "res_typical",
*      "mimcap_typical"
*     ]
*    }
*   ],
*   "supply_v": {
*    "vdd": [
*     2.97,
*     3.3,
*     3.63
*    ],
*    "vcm": [
*     1.485,
*     1.65,
*     1.815
*    ]
*   },
*   "temperature_c": [
*    -40.0,
*    27.0,
*    125.0
*   ]
*  },
*  "analysis": {
*   "kind": "tran",
*   "args": "5e-09 5e-06"
*  },
*  "measurements": [
*   {
*    "name": "vlo_v",
*    "spice": ".meas tran vlo_v FIND v(vout) AT=9.9e-07",
*    "unit": "V"
*   },
*   {
*    "name": "vhi_v",
*    "spice": ".meas tran vhi_v FIND v(vout) AT=2.99e-06",
*    "unit": "V"
*   }
*  ],
*  "options": {
*   "timeout_s": 600,
*   "keep_artifacts": true,
*   "waveforms": true
*  },
*  "exclude": [
*   {
*    "process": "typical",
*    "temperature_c": -40.0,
*    "supply_v": {
*     "vdd": 2.97
*    }
*   },
*   {
*    "process": "typical",
*    "temperature_c": -40.0,
*    "supply_v": {
*     "vdd": 3.3
*    }
*   },
*   {
*    "process": "typical",
*    "temperature_c": -40.0,
*    "supply_v": {
*     "vdd": 3.63
*    }
*   },
*   {
*    "process": "typical",
*    "temperature_c": 27.0,
*    "supply_v": {
*     "vdd": 2.97
*    }
*   },
*   {
*    "process": "typical",
*    "temperature_c": 27.0,
*    "supply_v": {
*     "vdd": 3.63
*    }
*   },
*   {
*    "process": "typical",
*    "temperature_c": 125.0,
*    "supply_v": {
*     "vdd": 2.97
*    }
*   },
*   {
*    "process": "typical",
*    "temperature_c": 125.0,
*    "supply_v": {
*     "vdd": 3.3
*    }
*   },
*   {
*    "process": "typical",
*    "temperature_c": 125.0,
*    "supply_v": {
*     "vdd": 3.63
*    }
*   },
*   {
*    "process": "ff",
*    "temperature_c": -40.0,
*    "supply_v": {
*     "vdd": 2.97
*    }
*   },
*   {
*    "process": "ff",
*    "temperature_c": -40.0,
*    "supply_v": {
*     "vdd": 3.3
*    }
*   },
*   {
*    "process": "ff",
*    "temperature_c": 27.0,
*    "supply_v": {
*     "vdd": 2.97
*    }
*   },
*   {
*    "process": "ff",
*    "temperature_c": 27.0,
*    "supply_v": {
*     "vdd": 3.3
*    }
*   },
*   {
*    "process": "ff",
*    "temperature_c": 27.0,
*    "supply_v": {
*     "vdd": 3.63
*    }
*   },
*   {
*    "process": "ff",
*    "temperature_c": 125.0,
*    "supply_v": {
*     "vdd": 2.97
*    }
*   },
*   {
*    "process": "ff",
*    "temperature_c": 125.0,
*    "supply_v": {
*     "vdd": 3.3
*    }
*   },
*   {
*    "process": "ff",
*    "temperature_c": 125.0,
*    "supply_v": {
*     "vdd": 3.63
*    }
*   },
*   {
*    "process": "ss",
*    "temperature_c": -40.0,
*    "supply_v": {
*     "vdd": 2.97
*    }
*   },
*   {
*    "process": "ss",
*    "temperature_c": -40.0,
*    "supply_v": {
*     "vdd": 3.3
*    }
*   },
*   {
*    "process": "ss",
*    "temperature_c": -40.0,
*    "supply_v": {
*     "vdd": 3.63
*    }
*   },
*   {
*    "process": "ss",
*    "temperature_c": 27.0,
*    "supply_v": {
*     "vdd": 2.97
*    }
*   },
*   {
*    "process": "ss",
*    "temperature_c": 27.0,
*    "supply_v": {
*     "vdd": 3.3
*    }
*   },
*   {
*    "process": "ss",
*    "temperature_c": 27.0,
*    "supply_v": {
*     "vdd": 3.63
*    }
*   },
*   {
*    "process": "ss",
*    "temperature_c": 125.0,
*    "supply_v": {
*     "vdd": 3.3
*    }
*   },
*   {
*    "process": "ss",
*    "temperature_c": 125.0,
*    "supply_v": {
*     "vdd": 3.63
*    }
*   }
*  ],
*  "batch": {
*   "runner_version_check": "warn"
*  }
* }
* ---- conditions: klt sim request (ac_ibias12u_cl2p) ----
* {
*  "engine": "ngspice",
*  "models": {
*   "pdk": "gf180mcuD",
*   "lib": "libs.tech/ngspice/sm141064.ngspice"
*  },
*  "corners": {
*   "process": [
*    {
*     "name": "typical",
*     "sections": [
*      "typical",
*      "res_typical",
*      "mimcap_typical"
*     ]
*    },
*    {
*     "name": "fs",
*     "sections": [
*      "fs",
*      "res_typical",
*      "mimcap_typical"
*     ]
*    },
*    {
*     "name": "ss",
*     "sections": [
*      "ss",
*      "res_typical",
*      "mimcap_typical"
*     ]
*    }
*   ],
*   "supply_v": {
*    "vdd": [
*     2.97,
*     3.3
*    ],
*    "vcm": [
*     1.485,
*     1.65
*    ]
*   },
*   "temperature_c": [
*    27.0,
*    125.0
*   ]
*  },
*  "analysis": {
*   "kind": "ac",
*   "args": "dec 20 0.1 1e+09"
*  },
*  "measurements": [
*   {
*    "name": "a_first_db",
*    "spice": ".meas ac a_first_db FIND vdb(vout) AT=0.1",
*    "unit": "dB"
*   },
*   {
*    "name": "gbw_hz",
*    "spice": ".meas ac gbw_hz WHEN vdb(vout)=0 FALL=1",
*    "unit": "Hz"
*   },
*   {
*    "name": "ph_gbw_rad",
*    "spice": ".meas ac ph_gbw_rad FIND vp(vout) WHEN vdb(vout)=0 FALL=1",
*    "unit": "rad"
*   }
*  ],
*  "options": {
*   "timeout_s": 300,
*   "keep_artifacts": true,
*   "waveforms": true
*  },
*  "exclude": [
*   {
*    "process": "typical",
*    "temperature_c": 27.0,
*    "supply_v": {
*     "vdd": 2.97
*    }
*   },
*   {
*    "process": "typical",
*    "temperature_c": 125.0,
*    "supply_v": {
*     "vdd": 2.97
*    }
*   },
*   {
*    "process": "typical",
*    "temperature_c": 125.0,
*    "supply_v": {
*     "vdd": 3.3
*    }
*   },
*   {
*    "process": "fs",
*    "temperature_c": 27.0,
*    "supply_v": {
*     "vdd": 2.97
*    }
*   },
*   {
*    "process": "fs",
*    "temperature_c": 27.0,
*    "supply_v": {
*     "vdd": 3.3
*    }
*   },
*   {
*    "process": "fs",
*    "temperature_c": 125.0,
*    "supply_v": {
*     "vdd": 3.3
*    }
*   },
*   {
*    "process": "ss",
*    "temperature_c": 27.0,
*    "supply_v": {
*     "vdd": 2.97
*    }
*   },
*   {
*    "process": "ss",
*    "temperature_c": 27.0,
*    "supply_v": {
*     "vdd": 3.3
*    }
*   },
*   {
*    "process": "ss",
*    "temperature_c": 125.0,
*    "supply_v": {
*     "vdd": 3.3
*    }
*   }
*  ],
*  "batch": {
*   "runner_version_check": "warn"
*  }
* }
* ---- conditions: klt sim request (power_ibias12u) ----
* {
*  "engine": "ngspice",
*  "models": {
*   "pdk": "gf180mcuD",
*   "lib": "libs.tech/ngspice/sm141064.ngspice"
*  },
*  "corners": {
*   "process": [
*    {
*     "name": "typical",
*     "sections": [
*      "typical",
*      "res_typical",
*      "mimcap_typical"
*     ]
*    },
*    {
*     "name": "ff",
*     "sections": [
*      "ff",
*      "res_typical",
*      "mimcap_typical"
*     ]
*    },
*    {
*     "name": "ss",
*     "sections": [
*      "ss",
*      "res_typical",
*      "mimcap_typical"
*     ]
*    }
*   ],
*   "supply_v": {
*    "vdd": [
*     2.97,
*     3.3,
*     3.63
*    ],
*    "vcm": [
*     1.485,
*     1.65,
*     1.815
*    ]
*   },
*   "temperature_c": [
*    -40.0,
*    27.0,
*    125.0
*   ]
*  },
*  "analysis": {
*   "kind": "dc",
*   "args": "Ibias 1.2e-05 1.3e-05 1u"
*  },
*  "measurements": [
*   {
*    "name": "ivdd_a",
*    "spice": ".meas dc ivdd_a FIND i(vdd) AT=1.2e-05",
*    "unit": "A"
*   },
*   {
*    "name": "vout_v",
*    "spice": ".meas dc vout_v FIND v(vout) AT=1.2e-05",
*    "unit": "V"
*   }
*  ],
*  "options": {
*   "timeout_s": 600,
*   "keep_artifacts": true,
*   "waveforms": true
*  },
*  "exclude": [
*   {
*    "process": "typical",
*    "temperature_c": -40.0,
*    "supply_v": {
*     "vdd": 2.97
*    }
*   },
*   {
*    "process": "typical",
*    "temperature_c": -40.0,
*    "supply_v": {
*     "vdd": 3.3
*    }
*   },
*   {
*    "process": "typical",
*    "temperature_c": -40.0,
*    "supply_v": {
*     "vdd": 3.63
*    }
*   },
*   {
*    "process": "typical",
*    "temperature_c": 27.0,
*    "supply_v": {
*     "vdd": 2.97
*    }
*   },
*   {
*    "process": "typical",
*    "temperature_c": 27.0,
*    "supply_v": {
*     "vdd": 3.63
*    }
*   },
*   {
*    "process": "typical",
*    "temperature_c": 125.0,
*    "supply_v": {
*     "vdd": 2.97
*    }
*   },
*   {
*    "process": "typical",
*    "temperature_c": 125.0,
*    "supply_v": {
*     "vdd": 3.3
*    }
*   },
*   {
*    "process": "typical",
*    "temperature_c": 125.0,
*    "supply_v": {
*     "vdd": 3.63
*    }
*   },
*   {
*    "process": "ff",
*    "temperature_c": -40.0,
*    "supply_v": {
*     "vdd": 2.97
*    }
*   },
*   {
*    "process": "ff",
*    "temperature_c": -40.0,
*    "supply_v": {
*     "vdd": 3.3
*    }
*   },
*   {
*    "process": "ff",
*    "temperature_c": 27.0,
*    "supply_v": {
*     "vdd": 2.97
*    }
*   },
*   {
*    "process": "ff",
*    "temperature_c": 27.0,
*    "supply_v": {
*     "vdd": 3.3
*    }
*   },
*   {
*    "process": "ff",
*    "temperature_c": 27.0,
*    "supply_v": {
*     "vdd": 3.63
*    }
*   },
*   {
*    "process": "ff",
*    "temperature_c": 125.0,
*    "supply_v": {
*     "vdd": 2.97
*    }
*   },
*   {
*    "process": "ff",
*    "temperature_c": 125.0,
*    "supply_v": {
*     "vdd": 3.3
*    }
*   },
*   {
*    "process": "ff",
*    "temperature_c": 125.0,
*    "supply_v": {
*     "vdd": 3.63
*    }
*   },
*   {
*    "process": "ss",
*    "temperature_c": -40.0,
*    "supply_v": {
*     "vdd": 2.97
*    }
*   },
*   {
*    "process": "ss",
*    "temperature_c": -40.0,
*    "supply_v": {
*     "vdd": 3.3
*    }
*   },
*   {
*    "process": "ss",
*    "temperature_c": -40.0,
*    "supply_v": {
*     "vdd": 3.63
*    }
*   },
*   {
*    "process": "ss",
*    "temperature_c": 27.0,
*    "supply_v": {
*     "vdd": 2.97
*    }
*   },
*   {
*    "process": "ss",
*    "temperature_c": 27.0,
*    "supply_v": {
*     "vdd": 3.3
*    }
*   },
*   {
*    "process": "ss",
*    "temperature_c": 27.0,
*    "supply_v": {
*     "vdd": 3.63
*    }
*   },
*   {
*    "process": "ss",
*    "temperature_c": 125.0,
*    "supply_v": {
*     "vdd": 3.3
*    }
*   },
*   {
*    "process": "ss",
*    "temperature_c": 125.0,
*    "supply_v": {
*     "vdd": 3.63
*    }
*   }
*  ],
*  "batch": {
*   "runner_version_check": "warn"
*  }
* }
* ---- conditions: klt sim request (slew_ibias12u_cl2p) ----
* {
*  "engine": "ngspice",
*  "models": {
*   "pdk": "gf180mcuD",
*   "lib": "libs.tech/ngspice/sm141064.ngspice"
*  },
*  "corners": {
*   "process": [
*    {
*     "name": "typical",
*     "sections": [
*      "typical",
*      "res_typical",
*      "mimcap_typical"
*     ]
*    },
*    {
*     "name": "ff",
*     "sections": [
*      "ff",
*      "res_typical",
*      "mimcap_typical"
*     ]
*    },
*    {
*     "name": "ss",
*     "sections": [
*      "ss",
*      "res_typical",
*      "mimcap_typical"
*     ]
*    }
*   ],
*   "supply_v": {
*    "vdd": [
*     2.97,
*     3.3,
*     3.63
*    ],
*    "vcm": [
*     1.485,
*     1.65,
*     1.815
*    ]
*   },
*   "temperature_c": [
*    -40.0,
*    27.0,
*    125.0
*   ]
*  },
*  "analysis": {
*   "kind": "tran",
*   "args": "5e-09 5e-06"
*  },
*  "measurements": [
*   {
*    "name": "vlo_v",
*    "spice": ".meas tran vlo_v FIND v(vout) AT=9.9e-07",
*    "unit": "V"
*   },
*   {
*    "name": "vhi_v",
*    "spice": ".meas tran vhi_v FIND v(vout) AT=2.99e-06",
*    "unit": "V"
*   }
*  ],
*  "options": {
*   "timeout_s": 600,
*   "keep_artifacts": true,
*   "waveforms": true
*  },
*  "exclude": [
*   {
*    "process": "typical",
*    "temperature_c": -40.0,
*    "supply_v": {
*     "vdd": 2.97
*    }
*   },
*   {
*    "process": "typical",
*    "temperature_c": -40.0,
*    "supply_v": {
*     "vdd": 3.3
*    }
*   },
*   {
*    "process": "typical",
*    "temperature_c": -40.0,
*    "supply_v": {
*     "vdd": 3.63
*    }
*   },
*   {
*    "process": "typical",
*    "temperature_c": 27.0,
*    "supply_v": {
*     "vdd": 2.97
*    }
*   },
*   {
*    "process": "typical",
*    "temperature_c": 27.0,
*    "supply_v": {
*     "vdd": 3.63
*    }
*   },
*   {
*    "process": "typical",
*    "temperature_c": 125.0,
*    "supply_v": {
*     "vdd": 2.97
*    }
*   },
*   {
*    "process": "typical",
*    "temperature_c": 125.0,
*    "supply_v": {
*     "vdd": 3.3
*    }
*   },
*   {
*    "process": "typical",
*    "temperature_c": 125.0,
*    "supply_v": {
*     "vdd": 3.63
*    }
*   },
*   {
*    "process": "ff",
*    "temperature_c": -40.0,
*    "supply_v": {
*     "vdd": 2.97
*    }
*   },
*   {
*    "process": "ff",
*    "temperature_c": -40.0,
*    "supply_v": {
*     "vdd": 3.3
*    }
*   },
*   {
*    "process": "ff",
*    "temperature_c": 27.0,
*    "supply_v": {
*     "vdd": 2.97
*    }
*   },
*   {
*    "process": "ff",
*    "temperature_c": 27.0,
*    "supply_v": {
*     "vdd": 3.3
*    }
*   },
*   {
*    "process": "ff",
*    "temperature_c": 27.0,
*    "supply_v": {
*     "vdd": 3.63
*    }
*   },
*   {
*    "process": "ff",
*    "temperature_c": 125.0,
*    "supply_v": {
*     "vdd": 2.97
*    }
*   },
*   {
*    "process": "ff",
*    "temperature_c": 125.0,
*    "supply_v": {
*     "vdd": 3.3
*    }
*   },
*   {
*    "process": "ff",
*    "temperature_c": 125.0,
*    "supply_v": {
*     "vdd": 3.63
*    }
*   },
*   {
*    "process": "ss",
*    "temperature_c": -40.0,
*    "supply_v": {
*     "vdd": 2.97
*    }
*   },
*   {
*    "process": "ss",
*    "temperature_c": -40.0,
*    "supply_v": {
*     "vdd": 3.3
*    }
*   },
*   {
*    "process": "ss",
*    "temperature_c": -40.0,
*    "supply_v": {
*     "vdd": 3.63
*    }
*   },
*   {
*    "process": "ss",
*    "temperature_c": 27.0,
*    "supply_v": {
*     "vdd": 2.97
*    }
*   },
*   {
*    "process": "ss",
*    "temperature_c": 27.0,
*    "supply_v": {
*     "vdd": 3.3
*    }
*   },
*   {
*    "process": "ss",
*    "temperature_c": 27.0,
*    "supply_v": {
*     "vdd": 3.63
*    }
*   },
*   {
*    "process": "ss",
*    "temperature_c": 125.0,
*    "supply_v": {
*     "vdd": 3.3
*    }
*   },
*   {
*    "process": "ss",
*    "temperature_c": 125.0,
*    "supply_v": {
*     "vdd": 3.63
*    }
*   }
*  ],
*  "batch": {
*   "runner_version_check": "warn"
*  }
* }
* ---- conditions: klt sim request (ac_ibias10u_cl1p) ----
* {
*  "engine": "ngspice",
*  "models": {
*   "pdk": "gf180mcuD",
*   "lib": "libs.tech/ngspice/sm141064.ngspice"
*  },
*  "corners": {
*   "process": [
*    {
*     "name": "typical",
*     "sections": [
*      "typical",
*      "res_typical",
*      "mimcap_typical"
*     ]
*    },
*    {
*     "name": "fs",
*     "sections": [
*      "fs",
*      "res_typical",
*      "mimcap_typical"
*     ]
*    },
*    {
*     "name": "ss",
*     "sections": [
*      "ss",
*      "res_typical",
*      "mimcap_typical"
*     ]
*    }
*   ],
*   "supply_v": {
*    "vdd": [
*     2.97,
*     3.3
*    ],
*    "vcm": [
*     1.485,
*     1.65
*    ]
*   },
*   "temperature_c": [
*    27.0,
*    125.0
*   ]
*  },
*  "analysis": {
*   "kind": "ac",
*   "args": "dec 20 0.1 1e+09"
*  },
*  "measurements": [
*   {
*    "name": "a_first_db",
*    "spice": ".meas ac a_first_db FIND vdb(vout) AT=0.1",
*    "unit": "dB"
*   },
*   {
*    "name": "gbw_hz",
*    "spice": ".meas ac gbw_hz WHEN vdb(vout)=0 FALL=1",
*    "unit": "Hz"
*   },
*   {
*    "name": "ph_gbw_rad",
*    "spice": ".meas ac ph_gbw_rad FIND vp(vout) WHEN vdb(vout)=0 FALL=1",
*    "unit": "rad"
*   }
*  ],
*  "options": {
*   "timeout_s": 300,
*   "keep_artifacts": true,
*   "waveforms": true
*  },
*  "exclude": [
*   {
*    "process": "typical",
*    "temperature_c": 27.0,
*    "supply_v": {
*     "vdd": 2.97
*    }
*   },
*   {
*    "process": "typical",
*    "temperature_c": 125.0,
*    "supply_v": {
*     "vdd": 2.97
*    }
*   },
*   {
*    "process": "typical",
*    "temperature_c": 125.0,
*    "supply_v": {
*     "vdd": 3.3
*    }
*   },
*   {
*    "process": "fs",
*    "temperature_c": 27.0,
*    "supply_v": {
*     "vdd": 2.97
*    }
*   },
*   {
*    "process": "fs",
*    "temperature_c": 27.0,
*    "supply_v": {
*     "vdd": 3.3
*    }
*   },
*   {
*    "process": "fs",
*    "temperature_c": 125.0,
*    "supply_v": {
*     "vdd": 3.3
*    }
*   },
*   {
*    "process": "ss",
*    "temperature_c": 27.0,
*    "supply_v": {
*     "vdd": 2.97
*    }
*   },
*   {
*    "process": "ss",
*    "temperature_c": 27.0,
*    "supply_v": {
*     "vdd": 3.3
*    }
*   },
*   {
*    "process": "ss",
*    "temperature_c": 125.0,
*    "supply_v": {
*     "vdd": 3.3
*    }
*   }
*  ],
*  "batch": {
*   "runner_version_check": "warn"
*  }
* }
* ---- conditions: klt sim request (ac_ibias10u_cl4p) ----
* {
*  "engine": "ngspice",
*  "models": {
*   "pdk": "gf180mcuD",
*   "lib": "libs.tech/ngspice/sm141064.ngspice"
*  },
*  "corners": {
*   "process": [
*    {
*     "name": "typical",
*     "sections": [
*      "typical",
*      "res_typical",
*      "mimcap_typical"
*     ]
*    },
*    {
*     "name": "fs",
*     "sections": [
*      "fs",
*      "res_typical",
*      "mimcap_typical"
*     ]
*    },
*    {
*     "name": "ss",
*     "sections": [
*      "ss",
*      "res_typical",
*      "mimcap_typical"
*     ]
*    }
*   ],
*   "supply_v": {
*    "vdd": [
*     2.97,
*     3.3
*    ],
*    "vcm": [
*     1.485,
*     1.65
*    ]
*   },
*   "temperature_c": [
*    27.0,
*    125.0
*   ]
*  },
*  "analysis": {
*   "kind": "ac",
*   "args": "dec 20 0.1 1e+09"
*  },
*  "measurements": [
*   {
*    "name": "a_first_db",
*    "spice": ".meas ac a_first_db FIND vdb(vout) AT=0.1",
*    "unit": "dB"
*   },
*   {
*    "name": "gbw_hz",
*    "spice": ".meas ac gbw_hz WHEN vdb(vout)=0 FALL=1",
*    "unit": "Hz"
*   },
*   {
*    "name": "ph_gbw_rad",
*    "spice": ".meas ac ph_gbw_rad FIND vp(vout) WHEN vdb(vout)=0 FALL=1",
*    "unit": "rad"
*   }
*  ],
*  "options": {
*   "timeout_s": 300,
*   "keep_artifacts": true,
*   "waveforms": true
*  },
*  "exclude": [
*   {
*    "process": "typical",
*    "temperature_c": 27.0,
*    "supply_v": {
*     "vdd": 2.97
*    }
*   },
*   {
*    "process": "typical",
*    "temperature_c": 125.0,
*    "supply_v": {
*     "vdd": 2.97
*    }
*   },
*   {
*    "process": "typical",
*    "temperature_c": 125.0,
*    "supply_v": {
*     "vdd": 3.3
*    }
*   },
*   {
*    "process": "fs",
*    "temperature_c": 27.0,
*    "supply_v": {
*     "vdd": 2.97
*    }
*   },
*   {
*    "process": "fs",
*    "temperature_c": 27.0,
*    "supply_v": {
*     "vdd": 3.3
*    }
*   },
*   {
*    "process": "fs",
*    "temperature_c": 125.0,
*    "supply_v": {
*     "vdd": 3.3
*    }
*   },
*   {
*    "process": "ss",
*    "temperature_c": 27.0,
*    "supply_v": {
*     "vdd": 2.97
*    }
*   },
*   {
*    "process": "ss",
*    "temperature_c": 27.0,
*    "supply_v": {
*     "vdd": 3.3
*    }
*   },
*   {
*    "process": "ss",
*    "temperature_c": 125.0,
*    "supply_v": {
*     "vdd": 3.3
*    }
*   }
*  ],
*  "batch": {
*   "runner_version_check": "warn"
*  }
* }
* ---- conditions: klt sim request (ac_ibias10u_cl10p) ----
* {
*  "engine": "ngspice",
*  "models": {
*   "pdk": "gf180mcuD",
*   "lib": "libs.tech/ngspice/sm141064.ngspice"
*  },
*  "corners": {
*   "process": [
*    {
*     "name": "typical",
*     "sections": [
*      "typical",
*      "res_typical",
*      "mimcap_typical"
*     ]
*    },
*    {
*     "name": "fs",
*     "sections": [
*      "fs",
*      "res_typical",
*      "mimcap_typical"
*     ]
*    },
*    {
*     "name": "ss",
*     "sections": [
*      "ss",
*      "res_typical",
*      "mimcap_typical"
*     ]
*    }
*   ],
*   "supply_v": {
*    "vdd": [
*     2.97,
*     3.3
*    ],
*    "vcm": [
*     1.485,
*     1.65
*    ]
*   },
*   "temperature_c": [
*    27.0,
*    125.0
*   ]
*  },
*  "analysis": {
*   "kind": "ac",
*   "args": "dec 20 0.1 1e+09"
*  },
*  "measurements": [
*   {
*    "name": "a_first_db",
*    "spice": ".meas ac a_first_db FIND vdb(vout) AT=0.1",
*    "unit": "dB"
*   },
*   {
*    "name": "gbw_hz",
*    "spice": ".meas ac gbw_hz WHEN vdb(vout)=0 FALL=1",
*    "unit": "Hz"
*   },
*   {
*    "name": "ph_gbw_rad",
*    "spice": ".meas ac ph_gbw_rad FIND vp(vout) WHEN vdb(vout)=0 FALL=1",
*    "unit": "rad"
*   }
*  ],
*  "options": {
*   "timeout_s": 300,
*   "keep_artifacts": true,
*   "waveforms": true
*  },
*  "exclude": [
*   {
*    "process": "typical",
*    "temperature_c": 27.0,
*    "supply_v": {
*     "vdd": 2.97
*    }
*   },
*   {
*    "process": "typical",
*    "temperature_c": 125.0,
*    "supply_v": {
*     "vdd": 2.97
*    }
*   },
*   {
*    "process": "typical",
*    "temperature_c": 125.0,
*    "supply_v": {
*     "vdd": 3.3
*    }
*   },
*   {
*    "process": "fs",
*    "temperature_c": 27.0,
*    "supply_v": {
*     "vdd": 2.97
*    }
*   },
*   {
*    "process": "fs",
*    "temperature_c": 27.0,
*    "supply_v": {
*     "vdd": 3.3
*    }
*   },
*   {
*    "process": "fs",
*    "temperature_c": 125.0,
*    "supply_v": {
*     "vdd": 3.3
*    }
*   },
*   {
*    "process": "ss",
*    "temperature_c": 27.0,
*    "supply_v": {
*     "vdd": 2.97
*    }
*   },
*   {
*    "process": "ss",
*    "temperature_c": 27.0,
*    "supply_v": {
*     "vdd": 3.3
*    }
*   },
*   {
*    "process": "ss",
*    "temperature_c": 125.0,
*    "supply_v": {
*     "vdd": 3.3
*    }
*   }
*  ],
*  "batch": {
*   "runner_version_check": "warn"
*  }
* }

* ---- DUT (wrapper-normalised) ----
** sch_path: /home/ubuntu/GitHub/gf180-opamp/.loom/worktrees/issue-17/design/opamp_two_stage.sch
.subckt opamp_two_stage vdd vss vinp vinn vout ibias

*.iopin vdd
*.iopin vss
*.iopin vinp
*.iopin vinn
*.iopin vout
*.iopin ibias
XMB1 ibias ibias vss vss nfet_03v3 L=2u W=6u nf=2 ad='int((nf+1)/2) * W/nf * 0.18u' as='int((nf+2)/2) * W/nf * 0.18u' pd='2*int((nf+1)/2) * (W/nf + 0.18u)'
+ ps='2*int((nf+2)/2) * (W/nf + 0.18u)' nrd='0.18u / W' nrs='0.18u / W' sa=0 sb=0 sd=0 m=1
XM5 tail ibias vss vss nfet_03v3 L=2u W=6u nf=2 ad='int((nf+1)/2) * W/nf * 0.18u' as='int((nf+2)/2) * W/nf * 0.18u' pd='2*int((nf+1)/2) * (W/nf + 0.18u)'
+ ps='2*int((nf+2)/2) * (W/nf + 0.18u)' nrd='0.18u / W' nrs='0.18u / W' sa=0 sb=0 sd=0 m=1
XM1 n1 vinn tail vss nfet_03v3 L=1u W=3.6u nf=2 ad='int((nf+1)/2) * W/nf * 0.18u' as='int((nf+2)/2) * W/nf * 0.18u' pd='2*int((nf+1)/2) * (W/nf + 0.18u)'
+ ps='2*int((nf+2)/2) * (W/nf + 0.18u)' nrd='0.18u / W' nrs='0.18u / W' sa=0 sb=0 sd=0 m=1
XM2 n2 vinp tail vss nfet_03v3 L=1u W=3.6u nf=2 ad='int((nf+1)/2) * W/nf * 0.18u' as='int((nf+2)/2) * W/nf * 0.18u' pd='2*int((nf+1)/2) * (W/nf + 0.18u)'
+ ps='2*int((nf+2)/2) * (W/nf + 0.18u)' nrd='0.18u / W' nrs='0.18u / W' sa=0 sb=0 sd=0 m=1
XM3 n1 n1 vdd vdd pfet_03v3 L=1u W=6u nf=2 ad='int((nf+1)/2) * W/nf * 0.18u' as='int((nf+2)/2) * W/nf * 0.18u' pd='2*int((nf+1)/2) * (W/nf + 0.18u)'
+ ps='2*int((nf+2)/2) * (W/nf + 0.18u)' nrd='0.18u / W' nrs='0.18u / W' sa=0 sb=0 sd=0 m=1
XM4 n2 n1 vdd vdd pfet_03v3 L=1u W=6u nf=2 ad='int((nf+1)/2) * W/nf * 0.18u' as='int((nf+2)/2) * W/nf * 0.18u' pd='2*int((nf+1)/2) * (W/nf + 0.18u)'
+ ps='2*int((nf+2)/2) * (W/nf + 0.18u)' nrd='0.18u / W' nrs='0.18u / W' sa=0 sb=0 sd=0 m=1
XM6 vout n2 vdd vdd pfet_03v3 L=1u W=72u nf=24 ad='int((nf+1)/2) * W/nf * 0.18u' as='int((nf+2)/2) * W/nf * 0.18u' pd='2*int((nf+1)/2) * (W/nf + 0.18u)'
+ ps='2*int((nf+2)/2) * (W/nf + 0.18u)' nrd='0.18u / W' nrs='0.18u / W' sa=0 sb=0 sd=0 m=1
XM7 vout ibias vss vss nfet_03v3 L=2u W=36u nf=12 ad='int((nf+1)/2) * W/nf * 0.18u' as='int((nf+2)/2) * W/nf * 0.18u' pd='2*int((nf+1)/2) * (W/nf + 0.18u)'
+ ps='2*int((nf+2)/2) * (W/nf + 0.18u)' nrd='0.18u / W' nrs='0.18u / W' sa=0 sb=0 sd=0 m=1
XCC n2 nz cap_mim_2f0_m4m5_noshield c_width=17.4u c_length=17.4u m=1
XRZ vout nz vss ppolyf_u_1k r_width=2u r_length=4u m=1
.ends
* ---- testbench: sim/gain-gbw-pm/testbench/tb_gain_gbw_pm.spice (verbatim; Ibias / CL lines substituted per request) ----
* tb_gain_gbw_pm.spice -- open-loop AC testbench for the committed sized
* schematic (issue #38; spec rows: open-loop DC gain, GBW, phase margin).
*
* DEVICE UNDER TEST: the committed xschem export
* design/netlist/opamp_two_stage.spice, instantiated as `opamp_two_stage`
* (ports: vdd vss vinp vinn vout ibias). NO TRANSISTOR IS DECLARED IN THIS
* FILE -- every device, including the Miller cap CC and nulling resistor RZ,
* comes from the DUT include below. The driver (run_gain_gbw_pm.py)
* materialises `opamp_two_stage.dut.spice` from the committed export by the
* same wrapper normalisation design/check_dc_op.py uses (uncomment xschem's
* `**.subckt`/`**.ends`, drop the deck-terminating `.end`; nothing else is
* touched) and rewrites the two `.include` targets below to absolute paths
* of the per-run work directory. test_gain_gbw_pm.py guards that both
* includes are present and that no transistor is declared here.
*
* This file is a CIRCUIT BODY in `klt sim`'s sense: no `.lib`, `.temp`,
* `.control` or `.end`. `klt sim` adds the corner's `.lib` cards, `.temp`,
* the supply `alter`s and the `.ac` analysis.
*
* ---- Bias and load (design/README.md; spec/target-spec.md Sec.1) ----
*   - Ibias: 10 uA driven INTO the `ibias` node from vdd (the polarity
*     design/check_dc_op.py uses).
*   - CL = 2 pF [DR-1] on vout.
*   - Input common mode tracks VDD/2: `Vcm` and `Vdd` are swept together
*     by `klt sim` (corners.supply_v keys vdd and vcm move by index).
*   - Committed RZ/CC stay in the DUT; this bench neither tunes nor
*     bypasses them.
*
* ---- DC-closed, AC-open arrangement ----
* A huge inductor Lfb from vout to the inverting input vinn closes the loop
* at DC (unity-gain buffer: the amplifier self-biases at vinn = vout = VCM,
* the same operating point design/check_dc_op.py verifies) while being an
* AC open: |Z| = 2*pi*f*Lfb >= ~6e8 ohm even at the 0.1 Hz sweep start, far
* above the ~Mohm-class output resistance, so it does not load the output
* and the loop is open for every swept frequency. A huge capacitor Cfb from
* vinn to ground makes vinn an AC ground, so the AC stimulus on vinp is the
* whole differential input. The driver still divides by the ACTUAL
* differential phasor v(vinp)-v(vinn) rather than assuming it is 1.
*
* The Lfb/Cfb values are the `.param` line below; the driver rewrites that
* line (and only that line) for the feedback-isolation sweep that
* demonstrates the measured low-frequency plateau does not depend on the
* isolation (see the record). A SMALL Lfb loads the output and shows up as
* a spurious gain rise with frequency instead of a plateau -- that is the
* failure mode the plateau check exists to catch.
*
* ---- Polarity ----
* vinp is the non-inverting input: the plateau gain must come out
* positive-real (phase ~ 0 deg). The driver fails a point whose plateau
* phase is not within 10 deg of 0.

.include 'design.ngspice'
.include 'opamp_two_stage.dut.spice'

.param lfb=1e9 cfb=1e9

Vdd vdd 0 dc 3.3
Vcm vinp 0 dc 1.65 ac 1
Ibias vdd ibias dc 10u
Xdut vdd 0 vinp vinn vout ibias opamp_two_stage
Lfb vout vinn {lfb}
Cfb vinn 0 {cfb}
CL vout 0 2p

* ---- testbench: sim/slew-swing-power/testbench/tb_power.spice (verbatim; Ibias / CL lines substituted per request) ----
* tb_power.spice -- quiescent power, DC operating point (issue #44; spec row: quiescent power).
*
* DEVICE UNDER TEST: the committed xschem export
* design/netlist/opamp_two_stage.spice, instantiated as `opamp_two_stage`
* (ports: vdd vss vinp vinn vout ibias). NO TRANSISTOR IS DECLARED IN THIS
* FILE. The driver (run_slew_swing_power.py) materialises
* `opamp_two_stage.dut.spice` from the committed export by the same
* wrapper normalisation design/check_dc_op.py uses and rewrites the two
* `.include` targets below to absolute paths of the per-run work directory.
*
* CIRCUIT BODY in `klt sim`'s sense: no `.lib`, `.temp`, `.control` or
* `.end`; klt adds the corner's `.lib` cards, `.temp`, the supply alters
* and the analysis. Vdd and Vcm are swept together by index (VCM = VDD/2).
*
* Unity-gain follower (vinn = vout) with vinp at VCM: the amplifier
* self-biases at vout = VCM. Ibias = 10 uA drawn from vdd into `ibias`.
* NO LOAD of any kind on vout (no CL, no resistive load): the supply current
* is the amplifier's own quiescent current. Ibias is drawn through Vdd, so
* -i(Vdd) is the TOTAL supply current including the bias reference branch.
* The driver reads -i(Vdd) at Ibias = 10 uA (a one-step DC sweep of Ibias,
* the form every klt runner version supports; there is no `.meas op`).

.include 'design.ngspice'
.include 'opamp_two_stage.dut.spice'

Vdd vdd 0 dc 3.3
Vcm vinp 0 dc 1.65
Ibias vdd ibias dc 10u
Xdut vdd 0 vinp vout vout ibias opamp_two_stage

* ---- testbench: sim/slew-swing-power/testbench/tb_slew.spice (verbatim; Ibias / CL lines substituted per request) ----
* tb_slew.spice -- unity-gain follower large-signal step (issue #44; spec row: slew rate).
*
* DEVICE UNDER TEST: the committed xschem export
* design/netlist/opamp_two_stage.spice, instantiated as `opamp_two_stage`
* (ports: vdd vss vinp vinn vout ibias). NO TRANSISTOR IS DECLARED IN THIS
* FILE. The driver (run_slew_swing_power.py) materialises
* `opamp_two_stage.dut.spice` from the committed export by the same
* wrapper normalisation design/check_dc_op.py uses and rewrites the two
* `.include` targets below to absolute paths of the per-run work directory.
*
* CIRCUIT BODY in `klt sim`'s sense: no `.lib`, `.temp`, `.control` or
* `.end`; klt adds the corner's `.lib` cards, `.temp`, the supply alters
* and the analysis. Vdd and Vcm are swept together by index (VCM = VDD/2).
*
* Unity-gain follower (vinn = vout), CL = 2 pF [DR-1] on vout, no other load.
* Input = VCM + a +-0.5 V step (1.0 V peak-to-peak, fixed in volts, centred
* on VCM = VDD/2 so it tracks the supply through the Vcm alter): the step is
* far above the ~Itail/gm slewing onset, so the edges are slew-limited.
* Series construction (Vcm in series with Vstep) keeps the swept quantity a
* plain DC source, which every klt runner version alters correctly.
*
*   t = 0 .. 1 us   input low   (VCM - 0.5 V), output settles
*   t = 1 us        rising edge  (1 ns)
*   t = 3 us        falling edge (1 ns)
*   t = 5 us        end of run (output settled low->high->low)
*
* Pulse width 2 us / run 5 us leave >= 2 us after each edge, several tens of
* closed-loop time constants (GBW >= 10 MHz => tau <= ~16 ns).

.include 'design.ngspice'
.include 'opamp_two_stage.dut.spice'

Vdd vdd 0 dc 3.3
Vcm vcm 0 dc 1.65
Vstep vinp vcm dc 0 pulse(-0.5 0.5 1u 1n 1n 2u 100u)
Ibias vdd ibias dc 10u
Xdut vdd 0 vinp vout vout ibias opamp_two_stage
CL vout 0 2p

* Only the two nodes the driver reads are saved: a `save all` transient of the
* full amplifier is ~3.5 MB of ASCII rawfile per point, which the batch fleet
* converts/returns for all 45 points (see README, "Batch-fleet timing").
.save v(vinp) v(vout)
