* tb_gain_gbw_pm.spice -- open-loop AC testbench for the committed sized
* schematic (issue #38; spec rows: open-loop DC gain, GBW, phase margin).
*
* DEVICE UNDER TEST: the committed xschem export
* design/netlist/opamp_two_stage.spice, instantiated as `opamp_two_stage`
* (ports: vdd vss vinp vinn vout ibias). NO TRANSISTOR IS DECLARED IN THIS
* FILE -- every device, including the Miller cap CC and nulling resistor RZ,
* comes from the DUT include below. The driver (run_gain_gbw_pm.py)
* materialises `opamp_two_stage.dut.spice` from the committed export by the
* same wrapper normalisation design/check_dc_op.py uses (uncomment xschem's
* `**.subckt`/`**.ends`, drop the deck-terminating `.end`; nothing else is
* touched) and rewrites the two `.include` targets below to absolute paths
* of the per-run work directory. test_gain_gbw_pm.py guards that both
* includes are present and that no transistor is declared here.
*
* This file is a CIRCUIT BODY in `klt sim`'s sense: no `.lib`, `.temp`,
* `.control` or `.end`. `klt sim` adds the corner's `.lib` cards, `.temp`,
* the supply `alter`s and the `.ac` analysis.
*
* ---- Bias and load (design/README.md; spec/target-spec.md Sec.1) ----
*   - Ibias: 10 uA driven INTO the `ibias` node from vdd (the polarity
*     design/check_dc_op.py uses).
*   - CL = 2 pF [DR-1] on vout.
*   - Input common mode tracks VDD/2: `Vcm` and `Vdd` are swept together
*     by `klt sim` (corners.supply_v keys vdd and vcm move by index).
*   - Committed RZ/CC stay in the DUT; this bench neither tunes nor
*     bypasses them.
*
* ---- DC-closed, AC-open arrangement ----
* A huge inductor Lfb from vout to the inverting input vinn closes the loop
* at DC (unity-gain buffer: the amplifier self-biases at vinn = vout = VCM,
* the same operating point design/check_dc_op.py verifies) while being an
* AC open: |Z| = 2*pi*f*Lfb >= ~6e8 ohm even at the 0.1 Hz sweep start, far
* above the ~Mohm-class output resistance, so it does not load the output
* and the loop is open for every swept frequency. A huge capacitor Cfb from
* vinn to ground makes vinn an AC ground, so the AC stimulus on vinp is the
* whole differential input. The driver still divides by the ACTUAL
* differential phasor v(vinp)-v(vinn) rather than assuming it is 1.
*
* The Lfb/Cfb values are the `.param` line below; the driver rewrites that
* line (and only that line) for the feedback-isolation sweep that
* demonstrates the measured low-frequency plateau does not depend on the
* isolation (see the record). A SMALL Lfb loads the output and shows up as
* a spurious gain rise with frequency instead of a plateau -- that is the
* failure mode the plateau check exists to catch.
*
* ---- Polarity ----
* vinp is the non-inverting input: the plateau gain must come out
* positive-real (phase ~ 0 deg). The driver fails a point whose plateau
* phase is not within 10 deg of 0.

.include 'design.ngspice'
.include 'opamp_two_stage.dut.spice'

.param lfb=1e9 cfb=1e9

Vdd vdd 0 dc 3.3
Vcm vinp 0 dc 1.65 ac 1
Ibias vdd ibias dc 10u
Xdut vdd 0 vinp vinn vout ibias opamp_two_stage
Lfb vout vinn {lfb}
Cfb vinn 0 {cfb}
CL vout 0 2p
