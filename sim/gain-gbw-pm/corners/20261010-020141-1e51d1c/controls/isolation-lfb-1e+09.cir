* klt sim -- generated corner deck, do not edit
.lib /home/ubuntu/.volare/gf180mcuD/libs.tech/ngspice/sm141064.ngspice typical
.lib /home/ubuntu/.volare/gf180mcuD/libs.tech/ngspice/sm141064.ngspice res_typical
.lib /home/ubuntu/.volare/gf180mcuD/libs.tech/ngspice/sm141064.ngspice mimcap_typical
.include /tmp/gainpm-95htchss/isolation-lfb-1e+09/tb.spice
.temp 27.0
.meas ac a_first_db FIND vdb(vout) AT=0.1
.meas ac gbw_hz WHEN vdb(vout)=0 FALL=1
.meas ac ph_gbw_rad FIND vp(vout) WHEN vdb(vout)=0 FALL=1
.control
save all
alter vcm=1.65
alter vdd=3.3
set filetype=ascii
ac dec 20 0.1 1e+09
write /tmp/gainpm-95htchss/isolation-lfb-1e+09/out/typical_vcm1p650_vdd3p300V_27C/waveform.raw
quit
.endc
.end
