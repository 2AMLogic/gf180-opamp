* klt sim -- generated corner deck, do not edit
.lib /opt/pdk/gf180mcuD/libs.tech/ngspice/sm141064.ngspice sf
.lib /opt/pdk/gf180mcuD/libs.tech/ngspice/sm141064.ngspice res_ss
.lib /opt/pdk/gf180mcuD/libs.tech/ngspice/sm141064.ngspice mimcap_ss
.include /var/tmp/eda-job-klt-sim-aea648e8d3bc/inputs/netlist.cir
.temp 125.0
.meas ac a_first_db FIND vdb(vout) AT=0.1
.meas ac gbw_hz WHEN vdb(vout)=0 FALL=1
.meas ac ph_gbw_rad FIND vp(vout) WHEN vdb(vout)=0 FALL=1
.control
alter vcm=1.815
alter vdd=3.63
set filetype=ascii
ac dec 20 0.1 1e+09
write /var/tmp/eda-job-klt-sim-aea648e8d3bc/outputs/artifacts/sf__rnworst__cnworst_vcm1p815_vdd3p630V_125C/waveform.raw
quit
.endc
.end
