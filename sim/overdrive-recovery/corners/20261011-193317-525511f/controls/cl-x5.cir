* klt sim -- generated corner deck, do not edit
.lib /home/ubuntu/.volare/gf180mcuD/libs.tech/ngspice/sm141064.ngspice typical
.lib /home/ubuntu/.volare/gf180mcuD/libs.tech/ngspice/sm141064.ngspice res_typical
.lib /home/ubuntu/.volare/gf180mcuD/libs.tech/ngspice/sm141064.ngspice mimcap_typical
.include /tmp/overdrive-ldgymhhl/cl-x5/tb.spice
.temp 27.0
.meas tran vpre_v FIND v(vout) AT=3.9e-07
.meas tran vsat_hi_v MAX v(vout) FROM=4e-07 TO=9.9e-07
.meas tran vsat_lo_v MIN v(vout) FROM=2.6e-06 TO=3.19e-06
.meas tran vfinal_v FIND v(vout) AT=4.89e-06
.control
save all
alter vcm=1.65
alter vdd=3.3
set filetype=ascii
tran 5e-09 4.9e-06
write /tmp/overdrive-ldgymhhl/cl-x5/out/typical_vcm1p650_vdd3p300V_27C/waveform.raw
quit
.endc
.end
