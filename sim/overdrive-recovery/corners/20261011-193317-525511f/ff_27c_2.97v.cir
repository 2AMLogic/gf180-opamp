* klt sim -- generated corner deck, do not edit
.lib /opt/pdk/gf180mcuD/libs.tech/ngspice/sm141064.ngspice ff
.lib /opt/pdk/gf180mcuD/libs.tech/ngspice/sm141064.ngspice res_typical
.lib /opt/pdk/gf180mcuD/libs.tech/ngspice/sm141064.ngspice mimcap_typical
.include /var/tmp/eda-job-klt-sim-c29e88157c79/inputs/netlist.cir
.temp 27.0
.meas tran vpre_v FIND v(vout) AT=3.9e-07
.meas tran vsat_hi_v MAX v(vout) FROM=4e-07 TO=9.9e-07
.meas tran vsat_lo_v MIN v(vout) FROM=2.6e-06 TO=3.19e-06
.meas tran vfinal_v FIND v(vout) AT=4.89e-06
.control
alter vcm=1.485
alter vdd=2.97
set filetype=ascii
tran 5e-09 4.9e-06
write /var/tmp/eda-job-klt-sim-c29e88157c79/outputs/artifacts/ff_vcm1p485_vdd2p970V_27C/waveform.raw
quit
.endc
.end
