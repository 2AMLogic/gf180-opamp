* klt sim -- generated corner deck, do not edit
.lib /opt/pdk/gf180mcuD/libs.tech/ngspice/sm141064.ngspice typical
.lib /opt/pdk/gf180mcuD/libs.tech/ngspice/sm141064.ngspice res_typical
.lib /opt/pdk/gf180mcuD/libs.tech/ngspice/sm141064.ngspice mimcap_typical
.include /var/tmp/eda-job-klt-sim-a38e427e0aca/inputs/netlist.cir
.temp -40.0
.meas tran vfinal_v FIND v(vout) AT=7.19e-06
.meas tran vdd_final_v FIND v(vdd) AT=7.19e-06
.meas tran vout_max_v MAX v(vout)
.control
save all
alter vcm=1.485
alter vdd=2.97
set filetype=ascii
tran 5e-09 7.2e-06
write /var/tmp/eda-job-klt-sim-a38e427e0aca/outputs/artifacts/typical_vcm1p485_vdd2p970V_n40C/waveform.raw
quit
.endc
.end
