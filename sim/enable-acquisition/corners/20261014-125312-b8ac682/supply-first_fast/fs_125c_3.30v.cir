* klt sim -- generated corner deck, do not edit
.lib /opt/pdk/gf180mcuD/libs.tech/ngspice/sm141064.ngspice fs
.lib /opt/pdk/gf180mcuD/libs.tech/ngspice/sm141064.ngspice res_typical
.lib /opt/pdk/gf180mcuD/libs.tech/ngspice/sm141064.ngspice mimcap_typical
.include /var/tmp/eda-job-klt-sim-a38e427e0aca/inputs/netlist.cir
.temp 125.0
.meas tran vfinal_v FIND v(vout) AT=7.19e-06
.meas tran vdd_final_v FIND v(vdd) AT=7.19e-06
.meas tran vout_max_v MAX v(vout)
.control
save all
alter vcm=1.65
alter vdd=3.3
set filetype=ascii
tran 5e-09 7.2e-06
write /var/tmp/eda-job-klt-sim-a38e427e0aca/outputs/artifacts/fs_vcm1p650_vdd3p300V_125C/waveform.raw
quit
.endc
.end
