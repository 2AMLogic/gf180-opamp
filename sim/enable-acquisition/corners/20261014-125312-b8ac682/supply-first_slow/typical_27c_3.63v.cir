* klt sim -- generated corner deck, do not edit
.lib /opt/pdk/gf180mcuD/libs.tech/ngspice/sm141064.ngspice typical
.lib /opt/pdk/gf180mcuD/libs.tech/ngspice/sm141064.ngspice res_typical
.lib /opt/pdk/gf180mcuD/libs.tech/ngspice/sm141064.ngspice mimcap_typical
.include /var/tmp/eda-job-klt-sim-c6c7c4b670ae/inputs/netlist.cir
.temp 27.0
.meas tran vfinal_v FIND v(vout) AT=1.699e-05
.meas tran vdd_final_v FIND v(vdd) AT=1.699e-05
.meas tran vout_max_v MAX v(vout)
.control
save all
alter vcm=1.815
alter vdd=3.63
set filetype=ascii
tran 1e-08 1.7e-05
write /var/tmp/eda-job-klt-sim-c6c7c4b670ae/outputs/artifacts/typical_vcm1p815_vdd3p630V_27C/waveform.raw
quit
.endc
.end
