* klt sim -- generated corner deck, do not edit
.lib /opt/pdk/gf180mcuD/libs.tech/ngspice/sm141064.ngspice sf
.lib /opt/pdk/gf180mcuD/libs.tech/ngspice/sm141064.ngspice res_typical
.lib /opt/pdk/gf180mcuD/libs.tech/ngspice/sm141064.ngspice mimcap_typical
.include /var/tmp/eda-job-klt-sim-eed663683043/inputs/netlist.cir
.temp 125.0
.meas tran vfinal_v FIND v(vout) AT=5.09e-06
.meas tran vdd_final_v FIND v(vdd) AT=5.09e-06
.meas tran vout_max_v MAX v(vout)
.control
save all
alter vcm=1.485
alter vdd=2.97
set filetype=ascii
tran 5e-09 5.1e-06
write /var/tmp/eda-job-klt-sim-eed663683043/outputs/artifacts/sf_vcm1p485_vdd2p970V_125C/waveform.raw
quit
.endc
.end
