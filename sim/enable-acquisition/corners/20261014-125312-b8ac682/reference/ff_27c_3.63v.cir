* klt sim -- generated corner deck, do not edit
.lib /opt/pdk/gf180mcuD/libs.tech/ngspice/sm141064.ngspice ff
.lib /opt/pdk/gf180mcuD/libs.tech/ngspice/sm141064.ngspice res_typical
.lib /opt/pdk/gf180mcuD/libs.tech/ngspice/sm141064.ngspice mimcap_typical
.include /var/tmp/eda-job-klt-sim-fb25c8302f29/inputs/netlist.cir
.temp 27.0
.meas dc vref_v FIND v(vout) AT=1
.meas dc vinp_v FIND v(vinp) AT=1
.meas dc vdd_v FIND v(vdd) AT=1
.control
save all
alter vcm=1.815
alter vdd=3.63
dc Vrb 1 1.1 0.1
quit
.endc
.end
