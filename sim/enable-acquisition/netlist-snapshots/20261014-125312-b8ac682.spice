* netlist snapshot for record 20261014-125312-b8ac682 (issue #191)
* Reproduces the measured design: DUT contents, testbench, conditions.
* ---- conditions: klt sim requests (one per case; netlist path elided) ----
* ---- case simultaneous/fast ----
* {
*  "engine": "ngspice",
*  "models": {
*   "pdk": "gf180mcuD",
*   "lib": "libs.tech/ngspice/sm141064.ngspice"
*  },
*  "corners": {
*   "process": [
*    {
*     "name": "typical",
*     "sections": [
*      "typical",
*      "res_typical",
*      "mimcap_typical"
*     ]
*    },
*    {
*     "name": "ff",
*     "sections": [
*      "ff",
*      "res_typical",
*      "mimcap_typical"
*     ]
*    },
*    {
*     "name": "ss",
*     "sections": [
*      "ss",
*      "res_typical",
*      "mimcap_typical"
*     ]
*    },
*    {
*     "name": "fs",
*     "sections": [
*      "fs",
*      "res_typical",
*      "mimcap_typical"
*     ]
*    },
*    {
*     "name": "sf",
*     "sections": [
*      "sf",
*      "res_typical",
*      "mimcap_typical"
*     ]
*    }
*   ],
*   "supply_v": {
*    "vdd": [
*     2.97,
*     3.3,
*     3.63
*    ],
*    "vcm": [
*     1.485,
*     1.65,
*     1.815
*    ]
*   },
*   "temperature_c": [
*    -40.0,
*    27.0,
*    125.0
*   ]
*  },
*  "analysis": {
*   "kind": "tran",
*   "args": "5e-09 5.1e-06"
*  },
*  "measurements": [
*   {
*    "name": "vfinal_v",
*    "spice": ".meas tran vfinal_v FIND v(vout) AT=5.09e-06",
*    "unit": "V"
*   },
*   {
*    "name": "vdd_final_v",
*    "spice": ".meas tran vdd_final_v FIND v(vdd) AT=5.09e-06",
*    "unit": "V"
*   },
*   {
*    "name": "vout_max_v",
*    "spice": ".meas tran vout_max_v MAX v(vout)",
*    "unit": "V"
*   }
*  ],
*  "options": {
*   "timeout_s": 900,
*   "keep_artifacts": true,
*   "waveforms": true
*  },
*  "batch": {}
* }
* schedule .param values: {"t_vdd": 1e-06, "tr_s": 1e-07, "t_ib": 1e-06, "tr_b": 1e-07, "t_off": 1.0, "t_on2": 2.0}
* ---- case simultaneous/slow ----
* {
*  "engine": "ngspice",
*  "models": {
*   "pdk": "gf180mcuD",
*   "lib": "libs.tech/ngspice/sm141064.ngspice"
*  },
*  "corners": {
*   "process": [
*    {
*     "name": "typical",
*     "sections": [
*      "typical",
*      "res_typical",
*      "mimcap_typical"
*     ]
*    },
*    {
*     "name": "ff",
*     "sections": [
*      "ff",
*      "res_typical",
*      "mimcap_typical"
*     ]
*    },
*    {
*     "name": "ss",
*     "sections": [
*      "ss",
*      "res_typical",
*      "mimcap_typical"
*     ]
*    },
*    {
*     "name": "fs",
*     "sections": [
*      "fs",
*      "res_typical",
*      "mimcap_typical"
*     ]
*    },
*    {
*     "name": "sf",
*     "sections": [
*      "sf",
*      "res_typical",
*      "mimcap_typical"
*     ]
*    }
*   ],
*   "supply_v": {
*    "vdd": [
*     2.97,
*     3.3,
*     3.63
*    ],
*    "vcm": [
*     1.485,
*     1.65,
*     1.815
*    ]
*   },
*   "temperature_c": [
*    -40.0,
*    27.0,
*    125.0
*   ]
*  },
*  "analysis": {
*   "kind": "tran",
*   "args": "1e-08 1e-05"
*  },
*  "measurements": [
*   {
*    "name": "vfinal_v",
*    "spice": ".meas tran vfinal_v FIND v(vout) AT=9.99e-06",
*    "unit": "V"
*   },
*   {
*    "name": "vdd_final_v",
*    "spice": ".meas tran vdd_final_v FIND v(vdd) AT=9.99e-06",
*    "unit": "V"
*   },
*   {
*    "name": "vout_max_v",
*    "spice": ".meas tran vout_max_v MAX v(vout)",
*    "unit": "V"
*   }
*  ],
*  "options": {
*   "timeout_s": 900,
*   "keep_artifacts": true,
*   "waveforms": true
*  },
*  "batch": {}
* }
* schedule .param values: {"t_vdd": 1e-06, "tr_s": 5e-06, "t_ib": 1e-06, "tr_b": 5e-06, "t_off": 1.0, "t_on2": 2.0}
* ---- case supply-first/fast ----
* {
*  "engine": "ngspice",
*  "models": {
*   "pdk": "gf180mcuD",
*   "lib": "libs.tech/ngspice/sm141064.ngspice"
*  },
*  "corners": {
*   "process": [
*    {
*     "name": "typical",
*     "sections": [
*      "typical",
*      "res_typical",
*      "mimcap_typical"
*     ]
*    },
*    {
*     "name": "ff",
*     "sections": [
*      "ff",
*      "res_typical",
*      "mimcap_typical"
*     ]
*    },
*    {
*     "name": "ss",
*     "sections": [
*      "ss",
*      "res_typical",
*      "mimcap_typical"
*     ]
*    },
*    {
*     "name": "fs",
*     "sections": [
*      "fs",
*      "res_typical",
*      "mimcap_typical"
*     ]
*    },
*    {
*     "name": "sf",
*     "sections": [
*      "sf",
*      "res_typical",
*      "mimcap_typical"
*     ]
*    }
*   ],
*   "supply_v": {
*    "vdd": [
*     2.97,
*     3.3,
*     3.63
*    ],
*    "vcm": [
*     1.485,
*     1.65,
*     1.815
*    ]
*   },
*   "temperature_c": [
*    -40.0,
*    27.0,
*    125.0
*   ]
*  },
*  "analysis": {
*   "kind": "tran",
*   "args": "5e-09 7.2e-06"
*  },
*  "measurements": [
*   {
*    "name": "vfinal_v",
*    "spice": ".meas tran vfinal_v FIND v(vout) AT=7.19e-06",
*    "unit": "V"
*   },
*   {
*    "name": "vdd_final_v",
*    "spice": ".meas tran vdd_final_v FIND v(vdd) AT=7.19e-06",
*    "unit": "V"
*   },
*   {
*    "name": "vout_max_v",
*    "spice": ".meas tran vout_max_v MAX v(vout)",
*    "unit": "V"
*   }
*  ],
*  "options": {
*   "timeout_s": 900,
*   "keep_artifacts": true,
*   "waveforms": true
*  },
*  "batch": {}
* }
* schedule .param values: {"t_vdd": 1e-06, "tr_s": 1e-07, "t_ib": 3.1e-06, "tr_b": 1e-07, "t_off": 1.0, "t_on2": 2.0}
* ---- case supply-first/slow ----
* {
*  "engine": "ngspice",
*  "models": {
*   "pdk": "gf180mcuD",
*   "lib": "libs.tech/ngspice/sm141064.ngspice"
*  },
*  "corners": {
*   "process": [
*    {
*     "name": "typical",
*     "sections": [
*      "typical",
*      "res_typical",
*      "mimcap_typical"
*     ]
*    },
*    {
*     "name": "ff",
*     "sections": [
*      "ff",
*      "res_typical",
*      "mimcap_typical"
*     ]
*    },
*    {
*     "name": "ss",
*     "sections": [
*      "ss",
*      "res_typical",
*      "mimcap_typical"
*     ]
*    },
*    {
*     "name": "fs",
*     "sections": [
*      "fs",
*      "res_typical",
*      "mimcap_typical"
*     ]
*    },
*    {
*     "name": "sf",
*     "sections": [
*      "sf",
*      "res_typical",
*      "mimcap_typical"
*     ]
*    }
*   ],
*   "supply_v": {
*    "vdd": [
*     2.97,
*     3.3,
*     3.63
*    ],
*    "vcm": [
*     1.485,
*     1.65,
*     1.815
*    ]
*   },
*   "temperature_c": [
*    -40.0,
*    27.0,
*    125.0
*   ]
*  },
*  "analysis": {
*   "kind": "tran",
*   "args": "1e-08 1.7e-05"
*  },
*  "measurements": [
*   {
*    "name": "vfinal_v",
*    "spice": ".meas tran vfinal_v FIND v(vout) AT=1.699e-05",
*    "unit": "V"
*   },
*   {
*    "name": "vdd_final_v",
*    "spice": ".meas tran vdd_final_v FIND v(vdd) AT=1.699e-05",
*    "unit": "V"
*   },
*   {
*    "name": "vout_max_v",
*    "spice": ".meas tran vout_max_v MAX v(vout)",
*    "unit": "V"
*   }
*  ],
*  "options": {
*   "timeout_s": 900,
*   "keep_artifacts": true,
*   "waveforms": true
*  },
*  "batch": {}
* }
* schedule .param values: {"t_vdd": 1e-06, "tr_s": 5e-06, "t_ib": 8e-06, "tr_b": 5e-06, "t_off": 1.0, "t_on2": 2.0}
* ---- case bias-cycle/fast ----
* {
*  "engine": "ngspice",
*  "models": {
*   "pdk": "gf180mcuD",
*   "lib": "libs.tech/ngspice/sm141064.ngspice"
*  },
*  "corners": {
*   "process": [
*    {
*     "name": "typical",
*     "sections": [
*      "typical",
*      "res_typical",
*      "mimcap_typical"
*     ]
*    },
*    {
*     "name": "ff",
*     "sections": [
*      "ff",
*      "res_typical",
*      "mimcap_typical"
*     ]
*    },
*    {
*     "name": "ss",
*     "sections": [
*      "ss",
*      "res_typical",
*      "mimcap_typical"
*     ]
*    },
*    {
*     "name": "fs",
*     "sections": [
*      "fs",
*      "res_typical",
*      "mimcap_typical"
*     ]
*    },
*    {
*     "name": "sf",
*     "sections": [
*      "sf",
*      "res_typical",
*      "mimcap_typical"
*     ]
*    }
*   ],
*   "supply_v": {
*    "vdd": [
*     2.97,
*     3.3,
*     3.63
*    ],
*    "vcm": [
*     1.485,
*     1.65,
*     1.815
*    ]
*   },
*   "temperature_c": [
*    -40.0,
*    27.0,
*    125.0
*   ]
*  },
*  "analysis": {
*   "kind": "tran",
*   "args": "5e-09 1.34e-05"
*  },
*  "measurements": [
*   {
*    "name": "vfinal_v",
*    "spice": ".meas tran vfinal_v FIND v(vout) AT=1.339e-05",
*    "unit": "V"
*   },
*   {
*    "name": "vdd_final_v",
*    "spice": ".meas tran vdd_final_v FIND v(vdd) AT=1.339e-05",
*    "unit": "V"
*   },
*   {
*    "name": "vout_max_v",
*    "spice": ".meas tran vout_max_v MAX v(vout)",
*    "unit": "V"
*   }
*  ],
*  "options": {
*   "timeout_s": 900,
*   "keep_artifacts": true,
*   "waveforms": true
*  },
*  "batch": {}
* }
* schedule .param values: {"t_vdd": 1e-06, "tr_s": 1e-07, "t_ib": 3.1e-06, "tr_b": 1e-07, "t_off": 7.2e-06, "t_on2": 9.3e-06}
* ---- case bias-cycle/slow ----
* {
*  "engine": "ngspice",
*  "models": {
*   "pdk": "gf180mcuD",
*   "lib": "libs.tech/ngspice/sm141064.ngspice"
*  },
*  "corners": {
*   "process": [
*    {
*     "name": "typical",
*     "sections": [
*      "typical",
*      "res_typical",
*      "mimcap_typical"
*     ]
*    },
*    {
*     "name": "ff",
*     "sections": [
*      "ff",
*      "res_typical",
*      "mimcap_typical"
*     ]
*    },
*    {
*     "name": "ss",
*     "sections": [
*      "ss",
*      "res_typical",
*      "mimcap_typical"
*     ]
*    },
*    {
*     "name": "fs",
*     "sections": [
*      "fs",
*      "res_typical",
*      "mimcap_typical"
*     ]
*    },
*    {
*     "name": "sf",
*     "sections": [
*      "sf",
*      "res_typical",
*      "mimcap_typical"
*     ]
*    }
*   ],
*   "supply_v": {
*    "vdd": [
*     2.97,
*     3.3,
*     3.63
*    ],
*    "vcm": [
*     1.485,
*     1.65,
*     1.815
*    ]
*   },
*   "temperature_c": [
*    -40.0,
*    27.0,
*    125.0
*   ]
*  },
*  "analysis": {
*   "kind": "tran",
*   "args": "1e-08 3.3e-05"
*  },
*  "measurements": [
*   {
*    "name": "vfinal_v",
*    "spice": ".meas tran vfinal_v FIND v(vout) AT=3.299e-05",
*    "unit": "V"
*   },
*   {
*    "name": "vdd_final_v",
*    "spice": ".meas tran vdd_final_v FIND v(vdd) AT=3.299e-05",
*    "unit": "V"
*   },
*   {
*    "name": "vout_max_v",
*    "spice": ".meas tran vout_max_v MAX v(vout)",
*    "unit": "V"
*   }
*  ],
*  "options": {
*   "timeout_s": 900,
*   "keep_artifacts": true,
*   "waveforms": true
*  },
*  "batch": {}
* }
* schedule .param values: {"t_vdd": 1e-06, "tr_s": 5e-06, "t_ib": 8e-06, "tr_b": 5e-06, "t_off": 1.7e-05, "t_on2": 2.4e-05}

* ---- DUT: design/netlist/opamp_two_stage.spice, wrapper-normalised (file opamp_two_stage.dut.spice) ----
** sch_path: /home/ubuntu/GitHub/gf180-opamp/.loom/worktrees/issue-42/design/opamp_two_stage.sch
.subckt opamp_two_stage vdd vss vinp vinn vout ibias

*.iopin vdd
*.iopin vss
*.iopin vinp
*.iopin vinn
*.iopin vout
*.iopin ibias
XMB1 ibias ibias vss vss nfet_03v3 L=2u W=6u nf=2 ad='int((nf+1)/2) * W/nf * 0.18u' as='int((nf+2)/2) * W/nf * 0.18u' pd='2*int((nf+1)/2) * (W/nf + 0.18u)'
+ ps='2*int((nf+2)/2) * (W/nf + 0.18u)' nrd='0.18u / W' nrs='0.18u / W' sa=0 sb=0 sd=0 m=1
XM5 tail ibias vss vss nfet_03v3 L=2u W=6u nf=2 ad='int((nf+1)/2) * W/nf * 0.18u' as='int((nf+2)/2) * W/nf * 0.18u' pd='2*int((nf+1)/2) * (W/nf + 0.18u)'
+ ps='2*int((nf+2)/2) * (W/nf + 0.18u)' nrd='0.18u / W' nrs='0.18u / W' sa=0 sb=0 sd=0 m=1
XM1 n1 vinn tail vss nfet_03v3 L=1u W=3.6u nf=2 ad='int((nf+1)/2) * W/nf * 0.18u' as='int((nf+2)/2) * W/nf * 0.18u' pd='2*int((nf+1)/2) * (W/nf + 0.18u)'
+ ps='2*int((nf+2)/2) * (W/nf + 0.18u)' nrd='0.18u / W' nrs='0.18u / W' sa=0 sb=0 sd=0 m=1
XM2 n2 vinp tail vss nfet_03v3 L=1u W=3.6u nf=2 ad='int((nf+1)/2) * W/nf * 0.18u' as='int((nf+2)/2) * W/nf * 0.18u' pd='2*int((nf+1)/2) * (W/nf + 0.18u)'
+ ps='2*int((nf+2)/2) * (W/nf + 0.18u)' nrd='0.18u / W' nrs='0.18u / W' sa=0 sb=0 sd=0 m=1
XM3 n1 n1 vdd vdd pfet_03v3 L=1u W=6u nf=2 ad='int((nf+1)/2) * W/nf * 0.18u' as='int((nf+2)/2) * W/nf * 0.18u' pd='2*int((nf+1)/2) * (W/nf + 0.18u)'
+ ps='2*int((nf+2)/2) * (W/nf + 0.18u)' nrd='0.18u / W' nrs='0.18u / W' sa=0 sb=0 sd=0 m=1
XM4 n2 n1 vdd vdd pfet_03v3 L=1u W=6u nf=2 ad='int((nf+1)/2) * W/nf * 0.18u' as='int((nf+2)/2) * W/nf * 0.18u' pd='2*int((nf+1)/2) * (W/nf + 0.18u)'
+ ps='2*int((nf+2)/2) * (W/nf + 0.18u)' nrd='0.18u / W' nrs='0.18u / W' sa=0 sb=0 sd=0 m=1
XM6 vout n2 vdd vdd pfet_03v3 L=1u W=72u nf=24 ad='int((nf+1)/2) * W/nf * 0.18u' as='int((nf+2)/2) * W/nf * 0.18u' pd='2*int((nf+1)/2) * (W/nf + 0.18u)'
+ ps='2*int((nf+2)/2) * (W/nf + 0.18u)' nrd='0.18u / W' nrs='0.18u / W' sa=0 sb=0 sd=0 m=1
XM7 vout ibias vss vss nfet_03v3 L=2u W=36u nf=12 ad='int((nf+1)/2) * W/nf * 0.18u' as='int((nf+2)/2) * W/nf * 0.18u' pd='2*int((nf+1)/2) * (W/nf + 0.18u)'
+ ps='2*int((nf+2)/2) * (W/nf + 0.18u)' nrd='0.18u / W' nrs='0.18u / W' sa=0 sb=0 sd=0 m=1
XCC n2 nz cap_mim_2f0_m4m5_noshield c_width=16.8u c_length=16.8u m=1
XRZ vout nz vss ppolyf_u_1k r_width=2u r_length=22u m=1
.ends
* ---- testbench: sim/enable-acquisition/testbench/tb_enable.spice (verbatim; schedule .param lines are substituted per case as listed above) ----
* tb_enable.spice -- supply and external-bias enable acquisition of the unity-gain
* follower (issue #191; evidence only, no spec row, no startup bound).
*
* DEVICE UNDER TEST: the committed xschem export
* design/netlist/opamp_two_stage.spice, instantiated as `opamp_two_stage`
* (ports: vdd vss vinp vinn vout ibias). NO TRANSISTOR IS DECLARED IN THIS
* FILE. The driver (run_enable_acquisition.py) materialises
* `opamp_two_stage.dut.spice` from the committed export by the same
* wrapper normalisation design/check_dc_op.py uses and rewrites the two
* `.include` targets below to absolute paths of the per-run work directory.
*
* CIRCUIT BODY in `klt sim`'s sense: no `.lib`, `.temp`, `.control` or `.end`;
* klt adds the corner's `.lib` cards, `.temp`, the supply alters and the
* analysis. The swept quantities stay plain DC sources (Vdd, Vcm: the klt
* runner alters them by name, VCM = VDD/2 by index, as in every experiment in
* sim/); they are the FINAL (powered) levels. The ENABLE SEQUENCE is applied
* by two dimensionless 0..1 envelope sources (Vrs, Vrb) that gate the final
* levels through behavioural sources:
*
*   v(vdd)  = v(vddset) * v(rs)     the DUT rail, ramped from 0 V
*   v(vinp) = v(vcmset) * v(rs)     the input tracks the ramped rail at VDD/2
*                                   (no unexplained powered-off input drive)
*   I(ibias) = 10 uA * v(rb)        the external bias current, ramped from 0 A,
*                                   sourced from the DUT rail (as Ibias is in
*                                   every other bench)
*
* INITIAL STATE: every source is at 0 at t = 0 (both envelopes start at 0), so
* the transient starts with the rail at 0 V, the bias at 0 A, the input at
* 0 V and the output at 0 V -- NOT at the final powered operating point. The
* analysis is a plain `.tran` WITHOUT `uic`: ngspice solves the t = 0 point
* with all sources at zero (the trivial unpowered state), then integrates the
* ramps. The driver verifies this from the retained traces and rejects a
* point whose first samples are not unpowered/unbiased.
*
* Unity-gain follower (vinn = vout), CL = 2 pF [DR-1] on vout, no other load
* (the loading of tb_step.spice / tb_overdrive.spice).
*
* The enable schedule is set by the .param lines below. Their committed values
* are the simultaneous-enable fast-ramp scenario; the driver substitutes the
* scenario/ramp values (sim/enable-acquisition/measurement_config.py,
* SCENARIOS and RAMPS) by an exactly-one-match rewrite and the values used
* are recorded in every record. The ramp durations are DIAGNOSTIC experiment
* conditions, NOT a consumer guarantee and NOT a supply/bias slew
* requirement. Times beyond the run stop (1 s) mean "never happens".
*
*   t_vdd   rail ramp start        tr_s  rail ramp duration
*   t_ib    bias enable start      tr_b  bias ramp duration (enable and re-enable)
*   t_off   bias disable start     t_on2 bias re-enable start
*
* The pwl corner times must increase monotonically (t_ib + tr_b < t_off,
* t_off + tr_b < t_on2); the driver asserts that for every schedule.

.include 'design.ngspice'
.include 'opamp_two_stage.dut.spice'

.param t_vdd=1u
.param tr_s=100n
.param t_ib=1u
.param tr_b=100n
.param t_off=1
.param t_on2=2

Vdd vddset 0 dc 3.3
Vcm vcmset 0 dc 1.65
Vrs rs 0 pwl(0 0 {t_vdd} 0 {t_vdd+tr_s} 1)
Vrb rb 0 pwl(0 0 {t_ib} 0 {t_ib+tr_b} 1 {t_off} 1 {t_off+tr_b} 0 {t_on2} 0 {t_on2+tr_b} 1)
Bvdd vdd 0 V = v(vddset)*v(rs)
Bvin vinp 0 V = v(vcmset)*v(rs)
Bibias vdd ibias I = 10u*v(rb)
Xdut vdd 0 vinp vout vout ibias opamp_two_stage
CL vout 0 2p

* Retained traces: supply, bias envelope and bias-mirror node, input, output
* and the internal nodes of both stages (first-stage mirror, second-stage
* gate, Miller node, tail). Only these are saved (fleet rawfile size; see
* sim/slew-swing-power/README.md, "Batch-fleet timing").
.save v(vdd) v(rs) v(rb) v(ibias) v(vinp) v(vout) v(xdut.n1) v(xdut.n2) v(xdut.nz) v(xdut.tail)

* ---- klt-generated deck of the nominal point, simultaneous / fast ----
* | * klt sim -- generated corner deck, do not edit
* | .lib /opt/pdk/gf180mcuD/libs.tech/ngspice/sm141064.ngspice typical
* | .lib /opt/pdk/gf180mcuD/libs.tech/ngspice/sm141064.ngspice res_typical
* | .lib /opt/pdk/gf180mcuD/libs.tech/ngspice/sm141064.ngspice mimcap_typical
* | .include /var/tmp/eda-job-klt-sim-eed663683043/inputs/netlist.cir
* | .temp 27.0
* | .meas tran vfinal_v FIND v(vout) AT=5.09e-06
* | .meas tran vdd_final_v FIND v(vdd) AT=5.09e-06
* | .meas tran vout_max_v MAX v(vout)
* | .control
* | save all
* | alter vcm=1.65
* | alter vdd=3.3
* | set filetype=ascii
* | tran 5e-09 5.1e-06
* | write /var/tmp/eda-job-klt-sim-eed663683043/outputs/artifacts/typical_vcm1p650_vdd3p300V_27C/waveform.raw
* | quit
* | .endc
* | .end
