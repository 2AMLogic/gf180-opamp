* tb_slew.spice -- unity-gain follower large-signal step (issue #44; spec row: slew rate).
*
* DEVICE UNDER TEST: the committed xschem export
* design/netlist/opamp_two_stage.spice, instantiated as `opamp_two_stage`
* (ports: vdd vss vinp vinn vout ibias). NO TRANSISTOR IS DECLARED IN THIS
* FILE. The driver (run_slew_swing_power.py) materialises
* `opamp_two_stage.dut.spice` from the committed export by the same
* wrapper normalisation design/check_dc_op.py uses and rewrites the two
* `.include` targets below to absolute paths of the per-run work directory.
*
* CIRCUIT BODY in `klt sim`'s sense: no `.lib`, `.temp`, `.control` or
* `.end`; klt adds the corner's `.lib` cards, `.temp`, the supply alters
* and the analysis. Vdd and Vcm are swept together by index (VCM = VDD/2).
*
* Unity-gain follower (vinn = vout), CL = 2 pF [DR-1] on vout, no other load.
* Input = VCM + a +-0.5 V step (1.0 V peak-to-peak, fixed in volts, centred
* on VCM = VDD/2 so it tracks the supply through the Vcm alter): the step is
* far above the ~Itail/gm slewing onset, so the edges are slew-limited.
* Series construction (Vcm in series with Vstep) keeps the swept quantity a
* plain DC source, which every klt runner version alters correctly.
*
*   t = 0 .. 1 us   input low   (VCM - 0.5 V), output settles
*   t = 1 us        rising edge  (1 ns)
*   t = 3 us        falling edge (1 ns)
*   t = 5 us        end of run (output settled low->high->low)
*
* Pulse width 2 us / run 5 us leave >= 2 us after each edge, several tens of
* closed-loop time constants (GBW >= 10 MHz => tau <= ~16 ns).

.include 'design.ngspice'
.include 'opamp_two_stage.dut.spice'

Vdd vdd 0 dc 3.3
Vcm vcm 0 dc 1.65
Vstep vinp vcm dc 0 pulse(-0.5 0.5 1u 1n 1n 2u 100u)
Ibias vdd ibias dc 10u
Xdut vdd 0 vinp vout vout ibias opamp_two_stage
CL vout 0 2p

* Only the two nodes the driver reads are saved: a `save all` transient of the
* full amplifier is ~3.5 MB of ASCII rawfile per point, which the batch fleet
* converts/returns for all 45 points (see README, "Batch-fleet timing").
.save v(vinp) v(vout)
