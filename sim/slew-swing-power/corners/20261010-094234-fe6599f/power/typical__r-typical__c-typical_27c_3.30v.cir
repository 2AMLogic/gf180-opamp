* klt sim -- generated corner deck, do not edit
.lib /opt/pdk/gf180mcuD/libs.tech/ngspice/sm141064.ngspice typical
.lib /opt/pdk/gf180mcuD/libs.tech/ngspice/sm141064.ngspice res_typical
.lib /opt/pdk/gf180mcuD/libs.tech/ngspice/sm141064.ngspice mimcap_typical
.include /var/tmp/eda-job-klt-sim-e5bae53e95f4/inputs/netlist.cir
.temp 27.0
.meas dc ivdd_a FIND i(vdd) AT=1e-05
.meas dc vout_v FIND v(vout) AT=1e-05
.control
alter vcm=1.65
alter vdd=3.3
set filetype=ascii
dc Ibias 1e-05 1.1e-05 1u
write /var/tmp/eda-job-klt-sim-e5bae53e95f4/outputs/artifacts/typical__rntypical__cntypical_vcm1p650_vdd3p300V_27C/waveform.raw
quit
.endc
.end
