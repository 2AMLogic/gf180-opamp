* klt sim -- generated corner deck, do not edit
.lib /home/ubuntu/.ciel/gf180mcuD/libs.tech/ngspice/sm141064.ngspice typical
.lib /home/ubuntu/.ciel/gf180mcuD/libs.tech/ngspice/sm141064.ngspice res_typical
.lib /home/ubuntu/.ciel/gf180mcuD/libs.tech/ngspice/sm141064.ngspice mimcap_typical
.include /tmp/ssp-pas-de0g2bm4/ibias-zero-power/tb.spice
.temp 27.0
.meas dc ivdd_a FIND i(vdd) AT=0
.meas dc vout_v FIND v(vout) AT=0
.control
save all
alter vcm=1.65
alter vdd=3.3
set filetype=ascii
dc Ibias 0 1e-06 1u
write /tmp/ssp-pas-de0g2bm4/ibias-zero-power/out/typical_vcm1p650_vdd3p300V_27C/waveform.raw
quit
.endc
.end
