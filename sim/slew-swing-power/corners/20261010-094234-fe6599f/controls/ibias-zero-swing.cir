* klt sim -- generated corner deck, do not edit
.lib /home/ubuntu/.ciel/gf180mcuD/libs.tech/ngspice/sm141064.ngspice typical
.lib /home/ubuntu/.ciel/gf180mcuD/libs.tech/ngspice/sm141064.ngspice res_typical
.lib /home/ubuntu/.ciel/gf180mcuD/libs.tech/ngspice/sm141064.ngspice mimcap_typical
.include /tmp/ssp-pas-de0g2bm4/ibias-zero-swing/tb.spice
.temp 27.0
.meas dc vout_max_v MAX v(vout)
.meas dc vout_min_v MIN v(vout)
.control
save all
alter vcm=1.65
alter vdd=3.3
set filetype=ascii
dc Vin 0 3.63 0.005
write /tmp/ssp-pas-de0g2bm4/ibias-zero-swing/out/typical_vcm1p650_vdd3p300V_27C/waveform.raw
quit
.endc
.end
