* klt sim -- generated corner deck, do not edit
.lib /opt/pdk/gf180mcuD/libs.tech/ngspice/sm141064.ngspice ss
.lib /opt/pdk/gf180mcuD/libs.tech/ngspice/sm141064.ngspice res_typical
.lib /opt/pdk/gf180mcuD/libs.tech/ngspice/sm141064.ngspice mimcap_typical
.include /var/tmp/eda-job-klt-sim-e1e0b25a9fb4/inputs/netlist.cir
.temp 125.0
.meas dc ivdd_a FIND i(vdd) AT=1e-05
.meas dc vout_v FIND v(vout) AT=1e-05
.control
alter vcm=1.65
alter vdd=3.3
set filetype=ascii
dc Ibias 1e-05 1.1e-05 1u
write /var/tmp/eda-job-klt-sim-e1e0b25a9fb4/outputs/artifacts/ss_vcm1p650_vdd3p300V_125C/waveform.raw
quit
.endc
.end
