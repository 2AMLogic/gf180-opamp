* klt sim -- generated corner deck, do not edit
.lib /home/ubuntu/.volare/gf180mcuD/libs.tech/ngspice/sm141064.ngspice typical
.lib /home/ubuntu/.volare/gf180mcuD/libs.tech/ngspice/sm141064.ngspice res_typical
.lib /home/ubuntu/.volare/gf180mcuD/libs.tech/ngspice/sm141064.ngspice mimcap_typical
.include /tmp/ssp-yuujw554/ibias-half-power/tb.spice
.temp 27.0
.meas dc ivdd_a FIND i(vdd) AT=5e-06
.meas dc vout_v FIND v(vout) AT=5e-06
.control
save all
alter vcm=1.65
alter vdd=3.3
set filetype=ascii
dc Ibias 5e-06 6e-06 1u
write /tmp/ssp-yuujw554/ibias-half-power/out/typical_vcm1p650_vdd3p300V_27C/waveform.raw
quit
.endc
.end
