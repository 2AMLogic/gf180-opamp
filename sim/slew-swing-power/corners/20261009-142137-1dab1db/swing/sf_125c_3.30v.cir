* klt sim -- generated corner deck, do not edit
.lib /opt/pdk/gf180mcuD/libs.tech/ngspice/sm141064.ngspice sf
.lib /opt/pdk/gf180mcuD/libs.tech/ngspice/sm141064.ngspice res_typical
.lib /opt/pdk/gf180mcuD/libs.tech/ngspice/sm141064.ngspice mimcap_typical
.include /var/tmp/eda-job-klt-sim-26d68126ed4b/inputs/netlist.cir
.temp 125.0
.meas dc vout_max_v MAX v(vout)
.meas dc vout_min_v MIN v(vout)
.control
alter vcm=1.65
alter vdd=3.3
set filetype=ascii
dc Vin 0 3.63 0.005
write /var/tmp/eda-job-klt-sim-26d68126ed4b/outputs/artifacts/sf_vcm1p650_vdd3p300V_125C/waveform.raw
quit
.endc
.end
