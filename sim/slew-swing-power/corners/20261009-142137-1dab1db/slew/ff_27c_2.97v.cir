* klt sim -- generated corner deck, do not edit
.lib /opt/pdk/gf180mcuD/libs.tech/ngspice/sm141064.ngspice ff
.lib /opt/pdk/gf180mcuD/libs.tech/ngspice/sm141064.ngspice res_typical
.lib /opt/pdk/gf180mcuD/libs.tech/ngspice/sm141064.ngspice mimcap_typical
.include /var/tmp/eda-job-klt-sim-e25ca1c133e3/inputs/netlist.cir
.temp 27.0
.meas tran vlo_v FIND v(vout) AT=9.9e-07
.meas tran vhi_v FIND v(vout) AT=2.99e-06
.control
alter vcm=1.485
alter vdd=2.97
set filetype=ascii
tran 5e-09 5e-06
write /var/tmp/eda-job-klt-sim-e25ca1c133e3/outputs/artifacts/ff_vcm1p485_vdd2p970V_27C/waveform.raw
quit
.endc
.end
