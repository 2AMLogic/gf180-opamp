* klt sim -- generated corner deck, do not edit
.lib /opt/pdk/gf180mcuD/libs.tech/ngspice/sm141064.ngspice ss
.lib /opt/pdk/gf180mcuD/libs.tech/ngspice/sm141064.ngspice res_ff
.lib /opt/pdk/gf180mcuD/libs.tech/ngspice/sm141064.ngspice mimcap_typical
.include /var/tmp/eda-job-klt-sim-041b8d4c537b/inputs/netlist.cir
.temp -40.0
.meas dc vout_max_v MAX v(vout)
.meas dc vout_min_v MIN v(vout)
.control
alter vcm=1.65
alter vdd=3.3
set filetype=ascii
dc Vin 0 3.63 0.005
write /var/tmp/eda-job-klt-sim-041b8d4c537b/outputs/artifacts/ss__rnbest__cntypical_vcm1p650_vdd3p300V_n40C/waveform.raw
quit
.endc
.end
