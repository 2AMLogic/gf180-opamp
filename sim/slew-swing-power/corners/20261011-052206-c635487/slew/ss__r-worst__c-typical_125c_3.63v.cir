* klt sim -- generated corner deck, do not edit
.lib /opt/pdk/gf180mcuD/libs.tech/ngspice/sm141064.ngspice ss
.lib /opt/pdk/gf180mcuD/libs.tech/ngspice/sm141064.ngspice res_ss
.lib /opt/pdk/gf180mcuD/libs.tech/ngspice/sm141064.ngspice mimcap_typical
.include /var/tmp/eda-job-klt-sim-a81d6211aa85/inputs/netlist.cir
.temp 125.0
.meas tran vlo_v FIND v(vout) AT=9.9e-07
.meas tran vhi_v FIND v(vout) AT=2.99e-06
.control
alter vcm=1.815
alter vdd=3.63
set filetype=ascii
tran 5e-09 5e-06
write /var/tmp/eda-job-klt-sim-a81d6211aa85/outputs/artifacts/ss__rnworst__cntypical_vcm1p815_vdd3p630V_125C/waveform.raw
quit
.endc
.end
