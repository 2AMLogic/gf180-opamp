* klt sim -- generated corner deck, do not edit
.lib /opt/pdk/gf180mcuD/libs.tech/ngspice/sm141064.ngspice ss
.lib /opt/pdk/gf180mcuD/libs.tech/ngspice/sm141064.ngspice res_ff
.lib /opt/pdk/gf180mcuD/libs.tech/ngspice/sm141064.ngspice mimcap_ss
.include /var/tmp/eda-job-klt-sim-ccde919a1209/inputs/netlist.cir
.temp -40.0
.meas dc ivdd_a FIND i(vdd) AT=1e-05
.meas dc vout_v FIND v(vout) AT=1e-05
.control
save all
alter vcm=1.815
alter vdd=3.63
set filetype=ascii
dc Ibias 1e-05 1.1e-05 1u
write /var/tmp/eda-job-klt-sim-ccde919a1209/outputs/artifacts/ss__rnbest__cnworst_vcm1p815_vdd3p630V_n40C/waveform.raw
quit
.endc
.end
