* klt sim -- generated corner deck, do not edit
.lib /opt/pdk/gf180mcuD/libs.tech/ngspice/sm141064.ngspice sf
.lib /opt/pdk/gf180mcuD/libs.tech/ngspice/sm141064.ngspice res_ss
.lib /opt/pdk/gf180mcuD/libs.tech/ngspice/sm141064.ngspice mimcap_ff
.include /var/tmp/eda-job-klt-sim-ccde919a1209/inputs/netlist.cir
.temp -40.0
.meas dc ivdd_a FIND i(vdd) AT=1e-05
.meas dc vout_v FIND v(vout) AT=1e-05
.control
save all
alter vcm=1.485
alter vdd=2.97
set filetype=ascii
dc Ibias 1e-05 1.1e-05 1u
write /var/tmp/eda-job-klt-sim-ccde919a1209/outputs/artifacts/sf__rnworst__cnbest_vcm1p485_vdd2p970V_n40C/waveform.raw
quit
.endc
.end
