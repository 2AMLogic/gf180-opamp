* klt sim -- generated corner deck, do not edit
.lib /opt/pdk/gf180mcuD/libs.tech/ngspice/sm141064.ngspice ss
.lib /opt/pdk/gf180mcuD/libs.tech/ngspice/sm141064.ngspice res_ss
.lib /opt/pdk/gf180mcuD/libs.tech/ngspice/sm141064.ngspice mimcap_ff
.include /var/tmp/eda-job-klt-sim-5b9ff955401b/inputs/netlist.cir
.temp 125.0
.meas tran vlo_v FIND v(vout) AT=9.9e-07
.meas tran vhi_v FIND v(vout) AT=2.99e-06
.control
save all
alter vcm=1.65
alter vdd=3.3
set filetype=ascii
tran 5e-09 5e-06
write /var/tmp/eda-job-klt-sim-5b9ff955401b/outputs/artifacts/ss__rnworst__cnbest_vcm1p650_vdd3p300V_125C/waveform.raw
quit
.endc
.end
