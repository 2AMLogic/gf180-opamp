* klt sim -- generated corner deck, do not edit
.lib /opt/pdk/gf180mcuD/libs.tech/ngspice/sm141064.ngspice fs
.lib /opt/pdk/gf180mcuD/libs.tech/ngspice/sm141064.ngspice res_typical
.lib /opt/pdk/gf180mcuD/libs.tech/ngspice/sm141064.ngspice mimcap_typical
.include /var/tmp/eda-job-klt-sim-b7f4ec5a20b9/inputs/netlist.cir
.temp -40.0
.meas dc vout_max_v MAX v(vout)
.meas dc vout_min_v MIN v(vout)
.control
save all
alter vcm=1.815
alter vdd=3.63
set filetype=ascii
dc Vin 0 3.63 0.005
write /var/tmp/eda-job-klt-sim-b7f4ec5a20b9/outputs/artifacts/fs__rntypical__cntypical_vcm1p815_vdd3p630V_n40C/waveform.raw
quit
.endc
.end
